TI TPS54360 transient model, 5v actual compensation, Vin=8.0
.include /home/lolz0r/repros/wpc_power_driver_cost/variants/jlcpcb/.scratch/vendor-models/SLVMCT7/TPS54360_PSPICE_TRANS/TPS54360_TRANS.LIB
.include /home/lolz0r/repros/wpc_power_driver_cost/variants/jlcpcb/tools/spice/models.lib
Vin vin 0 PWL(0 0 100u 8.0)
Rin vin vinf .02
Cin vinf 0 20u
XU boot comp en 0 sw rt vinf fb 0 TPS54360_TRANS
Ren1 vinf en 118k
Ren2 en 0 29.4k
Rrt rt 0 240k
Cboot boot sw 100n
Rfb1 vout fb 11.3k
Rfb2 fb 0 2.1k
Rc comp cc 33.2k
Cc cc 0 33n
Cp comp 0 470p
Dcatch 0 sw DB560C
L1 sw linductor 10u
Rdcr linductor vout .025
Cout1 vout c1 330u
Resr1 c1 0 .045
Cout2 vout c2 330u
Resr2 c2 0 .045
Cc3 vout 0 10u
Rload vout 0 5.105
Istep vout 0 PWL(0 0 4.5m 0 4.501m 2.0 6m 2.0 6.001m 0)
.save v(vout) v(sw) v(comp) i(L1)
.options reltol=.005 abstol=1u vntol=1m method=gear
.tran 100n 8m
.control
run
meas tran output_ss AVG v(vout) from=4m to=4.5m
meas tran output_peak MAX v(vout)
meas tran step_min MIN v(vout) from=4.5m to=5m
meas tran removal_peak MAX v(vout) from=6m to=7m
meas tran highload_ss AVG v(vout) from=5.5m to=6m
meas tran inductor_peak MAX i(L1)
meas tran inductor_running_peak MAX i(L1) from=4m to=8m
.endc
.end
