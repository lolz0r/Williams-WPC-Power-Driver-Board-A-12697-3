U21 reservoir candidate: flasher_only_f60_line1.1_esr0.02_imb1_phase0; 10 W constant-power regulator approximation
.include /home/lolz0r/repros/wpc_power_driver_cost/variants/jlcpcb/tools/spice/models.lib
Vsecondary secp secn SIN(0 24.86 60 0 0 0)
Rsec1 secp acp .05
Rsec2 secn acn .05
Dbridge1 acp raw DSCH20100
Dbridge2 acn raw DSCH20100
Dbridge3 0 acp DSCH20100
Dbridge4 0 acn DSCH20100
Rc11 raw c11_stored 0.02
Cc11 c11_stored 0 12000u
Bflashers raw 0 I=2.5*tanh(v(raw)/1)
Rbleed raw 0 5000
Bbuck raw 0 I=0/max(v(raw),4.5)*min(max((time-20m)/10m,0),1)
.save v(raw) v(raw) v(acp) i(Vsecondary) @dbridge1[id] @dbridge2[id]  @cc11[i]
.options method=gear reltol=.0001 abstol=100n vntol=10u klu itl4=100
.tran 10u .5 0 10u uic
.control
set numdgt=12
run
let sim_end=time[length(time)-1]
print sim_end
meas tran input_min MIN v(raw) from=.4 to=.5
meas tran input_max MAX v(raw) from=.4 to=.5
meas tran bridge_peak MAX @dbridge1[id]
meas tran secondary_rms RMS i(Vsecondary) from=.4 to=.5
let bridge_i2=@dbridge1[id]^2
meas tran bridge_i2t_start INTEG bridge_i2 from=0 to=.03
let bridge_p=v(acp,raw)*@dbridge1[id]
meas tran bridge_power AVG bridge_p from=.4 to=.5
meas tran rms_c11 RMS @cc11[i] from=.4 to=.5
.endc
.end
