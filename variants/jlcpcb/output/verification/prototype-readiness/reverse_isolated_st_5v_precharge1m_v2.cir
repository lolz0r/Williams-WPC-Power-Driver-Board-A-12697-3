TI TPS54360 transient model, 5v actual compensation, Vin=15.34
.include /home/lolz0r/repros/wpc_power_driver_cost/variants/jlcpcb/.scratch/vendor-models/SLVMCT7/TPS54360_PSPICE_TRANS/TPS54360_TRANS.LIB
.include /home/lolz0r/repros/wpc_power_driver_cost/variants/jlcpcb/tools/spice/models.lib

Cin local_input 0 20u
XU boot comp en 0 sw rt local_input fb 0 TPS54360_TRANS
Ren1 local_input en 118k
Ren2 en 0 29.4k
Rrt rt 0 240k
Cboot boot sw 100n
Rfb1 vout fb 11.3k
Rfb2 fb 0 2.1k
Rc comp cc 33.2k
Cc cc 0 33n
Cp comp 0 470p
Dcatch 0 sw DB560C
L1 sw linductor 10u
Rdcr linductor vout .025
Cout1 vout c1 330u IC=5.105
Resr1 c1 0 .045
Cout2 vout c2 330u IC=5.105
Resr2 c2 0 .045
Cc3 vout 0 10u IC=5.105
Rload vout 0 5.105

* AC secondary, winding resistance, four Schottky diodes and reservoir.
Bsecondary secp secn V=11.43*sin(2*3.141592653589793*60*time)*min(time/100u,1)
Rsec1 secp acp .05
Rsec2 secn acn .05
Dbridge1 acp vinf DSCH20100
Dbridge2 acn vinf DSCH20100
Dbridge3 0 acp DSCH20100
Dbridge4 0 acn DSCH20100
Creservoir stored 0 8000u
Rreservoir stored vinf .05
Rrawbleed vinf 0 5000

Vbypass vout bypass 0
Dbypass bypass local_input DSCH20100
Dinput vinf local_input DSCH20100
.save v(local_input) i(Vbypass) v(bypass) v(vout) v(vinf) v(en) v(sw) i(L1) @d.xu.d_u8_d13[id]
.options reltol=.005 abstol=1u vntol=1m method=gear klu itl4=100
.tran 1u 0.001 0 250n uic
.control
set numdgt=12
run
let sim_end=time[length(time)-1]
print sim_end
meas tran output_peak MAX v(vout)
meas tran output_min MIN v(vout)
meas tran inductor_peak MAX i(L1)
meas tran inductor_min MIN i(L1)
meas tran body_reverse_peak MAX @d.xu.d_u8_d13[id]
meas tran input_min MIN v(vinf)
meas tran bypass_peak MAX i(Vbypass)
let bypass_power=v(bypass,local_input)*i(Vbypass)
meas tran bypass_energy INTEG bypass_power
let bypass_i2=i(Vbypass)^2
meas tran bypass_i2t INTEG bypass_i2
set wr_singlescale
set wr_vecnames
linearize v(vout) v(vinf) v(en) i(L1)
wrdata /home/lolz0r/repros/wpc_power_driver_cost/variants/jlcpcb/output/verification/prototype-readiness/reverse_isolated_st_5v_precharge1m_v2.csv v(vout) v(vinf) v(en) i(L1)
.endc
.end
