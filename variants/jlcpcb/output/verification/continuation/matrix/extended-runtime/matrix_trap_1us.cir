All 64 lamp paths, raw ROM row/column strobes, 20.69 V
.include /home/lolz0r/repros/wpc_power_driver_cost/variants/jlcpcb/tools/spice/models.lib
Vrail rail 0 20.69
Vcc vcc 0 5
Rref vcc ref 1k
Dref1 ref mid D1N4148
Dref2 mid 0 D1N4148
Vdriverow0 row0cmd 0 PWL(
+ 0.000000000000 4.50
+ 0.001840980000 4.50
+ 0.001841000000 0.00
+ 0.001846980000 0.00
+ 0.001847000000 4.50
+ 0.003888980000 4.50
+ 0.003889000000 0.00
+ 0.003894980000 0.00
+ 0.003895000000 4.50
+ 0.005934480000 4.50
+ 0.005934500000 0.00
+ 0.005940480000 0.00
+ 0.005940500000 4.50
+ 0.008054980000 4.50
+ 0.008055000000 0.00
+ 0.008060980000 0.00
+ 0.008061000000 4.50
+ 0.010041980000 4.50
+ 0.010042000000 0.00
+ 0.010047980000 0.00
+ 0.010048000000 4.50
+ 0.012078480000 4.50
+ 0.012078500000 0.00
+ 0.012084480000 0.00
+ 0.012084500000 4.50
+ 0.014126980000 4.50
+ 0.014127000000 0.00
+ 0.014132980000 0.00
+ 0.014133000000 4.50
+ 0.016175480000 4.50
+ 0.016175500000 0.00
+ 0.016181480000 0.00
+ 0.016181500000 4.50
+ 0.018227480000 4.50
+ 0.018227500000 0.00
+ 0.018233480000 0.00
+ 0.018233500000 4.50
+ 0.020271480000 4.50
+ 0.020271500000 0.00
+ 0.020277480000 0.00
+ 0.020277500000 4.50
+ 0.022318480000 4.50
+ 0.022318500000 0.00
+ 0.022324480000 0.00
+ 0.022324500000 4.50
+ 0.024383480000 4.50
+ 0.024383500000 0.00
+ 0.024389480000 0.00
+ 0.024389500000 4.50
+ 0.026425480000 4.50
+ 0.026425500000 0.00
+ 0.026431480000 0.00
+ 0.026431500000 4.50
+ 0.028462480000 4.50
+ 0.028462500000 0.00
+ 0.028468480000 0.00
+ 0.028468500000 4.50
+ 0.030511480000 4.50
+ 0.030511500000 0.00
+ 0.030517480000 0.00
+ 0.030517500000 4.50
+ 0.032559480000 4.50
+ 0.032559500000 0.00
+ 0.032565480000 0.00
+ 0.032565500000 4.50
+ 0.034610980000 4.50
+ 0.034611000000 0.00
+ 0.034616980000 0.00
+ 0.034617000000 4.50
+ 0.036654980000 4.50
+ 0.036655000000 0.00
+ 0.036660980000 0.00
+ 0.036661000000 4.50
+ 0.038703980000 4.50
+ 0.038704000000 0.00
+ 0.038709980000 0.00
+ 0.038710000000 4.50
+ 0.040766980000 4.50
+ 0.040767000000 0.00
+ 0.040772980000 0.00
+ 0.040773000000 4.50
+ 0.042812980000 4.50
+ 0.042813000000 0.00
+ 0.042818980000 0.00
+ 0.042819000000 4.50
+ 0.044846480000 4.50
+ 0.044846500000 0.00
+ 0.044852480000 0.00
+ 0.044852500000 4.50
+ 0.046895480000 4.50
+ 0.046895500000 0.00
+ 0.046901480000 0.00
+ 0.046901500000 4.50
+ 0.048943480000 4.50
+ 0.048943500000 0.00
+ 0.048949480000 0.00
+ 0.048949500000 4.50
+ 0.050995980000 4.50
+ 0.050996000000 0.00
+ 0.051001980000 0.00
+ 0.051002000000 4.50
+ 0.053039980000 4.50
+ 0.053040000000 0.00
+ 0.053045980000 0.00
+ 0.053046000000 4.50
+ 0.055088480000 4.50
+ 0.055088500000 0.00
+ 0.055094480000 0.00
+ 0.055094500000 4.50
+ 0.057151980000 4.50
+ 0.057152000000 0.00
+ 0.057157980000 0.00
+ 0.057158000000 4.50
+ 0.059196980000 4.50
+ 0.059197000000 0.00
+ 0.059202980000 0.00
+ 0.059203000000 4.50
+ 0.061233980000 4.50
+ 0.061234000000 0.00
+ 0.061239980000 0.00
+ 0.061240000000 4.50
+ 0.063279480000 4.50
+ 0.063279500000 0.00
+ 0.063285480000 0.00
+ 0.063285500000 4.50
+ 0.065326480000 4.50
+ 0.065326500000 0.00
+ 0.065332480000 0.00
+ 0.065332500000 4.50
+ 0.067375480000 4.50
+ 0.067375500000 0.00
+ 0.067381480000 0.00
+ 0.067381500000 4.50
+ 0.069422980000 4.50
+ 0.069423000000 0.00
+ 0.069428980000 0.00
+ 0.069429000000 4.50
+ 0.071471980000 4.50
+ 0.071472000000 0.00
+ 0.071477980000 0.00
+ 0.071478000000 4.50
+ 0.073590980000 4.50
+ 0.073591000000 0.00
+ 0.073596980000 0.00
+ 0.073597000000 4.50
+ 0.075573980000 4.50
+ 0.075574000000 0.00
+ 0.075579980000 0.00
+ 0.075580000000 4.50
+ 0.077614480000 4.50
+ 0.077614500000 0.00
+ 0.077620480000 0.00
+ 0.077620500000 4.50
+ 0.079663980000 4.50
+ 0.079664000000 0.00
+ 0.079669980000 0.00
+ 0.079670000000 4.50
+ 0.081710480000 4.50
+ 0.081710500000 0.00
+ 0.081716480000 0.00
+ 0.081716500000 4.50
+ 0.083759980000 4.50
+ 0.083760000000 0.00
+ 0.083765980000 0.00
+ 0.083766000000 4.50
+ 0.085806480000 4.50
+ 0.085806500000 0.00
+ 0.085812480000 0.00
+ 0.085812500000 4.50
+ 0.087854980000 4.50
+ 0.087855000000 0.00
+ 0.087860980000 0.00
+ 0.087861000000 4.50
+ 0.089919980000 4.50
+ 0.089920000000 0.00
+ 0.089925980000 0.00
+ 0.089926000000 4.50
+ 0.091956480000 4.50
+ 0.091956500000 0.00
+ 0.091962480000 0.00
+ 0.091962500000 4.50
+ 0.093998980000 4.50
+ 0.093999000000 0.00
+ 0.094004980000 0.00
+ 0.094005000000 4.50
+ 0.096051480000 4.50
+ 0.096051500000 0.00
+ 0.096057480000 0.00
+ 0.096057500000 4.50
+ 0.098096980000 4.50
+ 0.098097000000 0.00
+ 0.098102980000 0.00
+ 0.098103000000 4.50
+ 0.100143980000 4.50
+ 0.100144000000 0.00
+ 0.100149980000 0.00
+ 0.100150000000 4.50
+ 0.102190480000 4.50
+ 0.102190500000 0.00
+ 0.102196480000 0.00
+ 0.102196500000 4.50
+ 0.104240480000 4.50
+ 0.104240500000 0.00
+ 0.104246480000 0.00
+ 0.104246500000 4.50
+ 0.106304480000 4.50
+ 0.106304500000 0.00
+ 0.106310480000 0.00
+ 0.106310500000 4.50
+ 0.108343480000 4.50
+ 0.108343500000 0.00
+ 0.108349480000 0.00
+ 0.108349500000 4.50
+ 0.110383980000 4.50
+ 0.110384000000 0.00
+ 0.110389980000 0.00
+ 0.110390000000 4.50
+ 0.112430980000 4.50
+ 0.112431000000 0.00
+ 0.112436980000 0.00
+ 0.112437000000 4.50
+ 0.114479480000 4.50
+ 0.114479500000 0.00
+ 0.114485480000 0.00
+ 0.114485500000 4.50
+ 0.116526480000 4.50
+ 0.116526500000 0.00
+ 0.116532480000 0.00
+ 0.116532500000 4.50
+ 0.118574980000 4.50
+ 0.118575000000 0.00
+ 0.118580980000 0.00
+ 0.118581000000 4.50
+ 0.120623980000 4.50
+ 0.120624000000 0.00
+ 0.120629980000 0.00
+ 0.120630000000 4.50
+ 0.122686980000 4.50
+ 0.122687000000 0.00
+ 0.122692980000 0.00
+ 0.122693000000 4.50
+ 0.124724980000 4.50
+ 0.124725000000 0.00
+ 0.124730980000 0.00
+ 0.124731000000 4.50
+ 0.126771980000 4.50
+ 0.126772000000 0.00
+ 0.126777980000 0.00
+ 0.126778000000 4.50
+ 0.128815980000 4.50
+ 0.128816000000 0.00
+ 0.128821980000 0.00
+ 0.128822000000 4.50
+ 0.130863480000 4.50
+ 0.130863500000 0.00
+ 0.130869480000 0.00
+ 0.130869500000 4.50
+ 0.132911480000 4.50
+ 0.132911500000 0.00
+ 0.132917480000 0.00
+ 0.132917500000 4.50
+ 0.134963480000 4.50
+ 0.134963500000 0.00
+ 0.134969480000 0.00
+ 0.134969500000 4.50
+ 0.137006480000 4.50
+ 0.137006500000 0.00
+ 0.137012480000 0.00
+ 0.137012500000 4.50
+ 0.139126980000 4.50
+ 0.139127000000 0.00
+ 0.139132980000 0.00
+ 0.139133000000 4.50
+ 0.141109980000 4.50
+ 0.141110000000 0.00
+ 0.141115980000 0.00
+ 0.141116000000 4.50
+ 0.143155480000 4.50
+ 0.143155500000 0.00
+ 0.143161480000 0.00
+ 0.143161500000 4.50
+ 0.145198480000 4.50
+ 0.145198500000 0.00
+ 0.145204480000 0.00
+ 0.145204500000 4.50
+ 0.147247480000 4.50
+ 0.147247500000 0.00
+ 0.147253480000 0.00
+ 0.147253500000 4.50
+ 0.149294480000 4.50
+ 0.149294500000 0.00
+ 0.149300480000 0.00
+ 0.149300500000 4.50
+ 0.151349980000 4.50
+ 0.151350000000 0.00
+ 0.151355980000 0.00
+ 0.151356000000 4.50
+ 0.153392980000 4.50
+ 0.153393000000 0.00
+ 0.153398980000 0.00
+ 0.153399000000 4.50
+ 0.155455980000 4.50
+ 0.155456000000 0.00
+ 0.155461980000 0.00
+ 0.155462000000 4.50
+ 0.157492980000 4.50
+ 0.157493000000 0.00
+ 0.157498980000 0.00
+ 0.157499000000 4.50
+ 0.159539480000 4.50
+ 0.159539500000 0.00
+ 0.159545480000 0.00
+ 0.159545500000 4.50
+ 0.161582480000 4.50
+ 0.161582500000 0.00
+ 0.161588480000 0.00
+ 0.161588500000 4.50
+ 0.163630480000 4.50
+ 0.163630500000 0.00
+ 0.163636480000 0.00
+ 0.163636500000 4.50
+ 0.165682980000 4.50
+ 0.165683000000 0.00
+ 0.165688980000 0.00
+ 0.165689000000 4.50
+ 0.167731480000 4.50
+ 0.167731500000 0.00
+ 0.167737480000 0.00
+ 0.167737500000 4.50
+ 0.169775480000 4.50
+ 0.169775500000 0.00
+ 0.169781480000 0.00
+ 0.169781500000 4.50
+ 0.171839480000 4.50
+ 0.171839500000 0.00
+ 0.171845480000 0.00
+ 0.171845500000 4.50
+ 0.173878980000 4.50
+ 0.173879000000 0.00
+ 0.173884980000 0.00
+ 0.173885000000 4.50
+ 0.175923980000 4.50
+ 0.175924000000 0.00
+ 0.175929980000 0.00
+ 0.175930000000 4.50
+ 0.177970980000 4.50
+ 0.177971000000 0.00
+ 0.177976980000 0.00
+ 0.177977000000 4.50
+ 0.180014480000 4.50
+ 0.180014500000 0.00
+ 0.180020480000 0.00
+ 0.180020500000 4.50
+ 0.182063480000 4.50
+ 0.182063500000 0.00
+ 0.182069480000 0.00
+ 0.182069500000 4.50
+ 0.184114980000 4.50
+ 0.184115000000 0.00
+ 0.184120980000 0.00
+ 0.184121000000 4.50
+ 0.186158980000 4.50
+ 0.186159000000 0.00
+ 0.186164980000 0.00
+ 0.186165000000 4.50
+ 0.188223480000 4.50
+ 0.188223500000 0.00
+ 0.188229480000 0.00
+ 0.188229500000 4.50
+ 0.190260480000 4.50
+ 0.190260500000 0.00
+ 0.190266480000 0.00
+ 0.190266500000 4.50
+ 0.192306480000 4.50
+ 0.192306500000 0.00
+ 0.192312480000 0.00
+ 0.192312500000 4.50
+ 0.194350980000 4.50
+ 0.194351000000 0.00
+ 0.194356980000 0.00
+ 0.194357000000 4.50
+ 0.196398980000 4.50
+ 0.196399000000 0.00
+ 0.196404980000 0.00
+ 0.196405000000 4.50
+ 0.198446480000 4.50
+ 0.198446500000 0.00
+ 0.198452480000 0.00
+ 0.198452500000 4.50
+ 0.200494480000 4.50
+ 0.200494500000 0.00
+ 0.200500480000 0.00
+ 0.200500500000 4.50
+ 0.202543480000 4.50
+ 0.202543500000 0.00
+ 0.202549480000 0.00
+ 0.202549500000 4.50
+ 0.204663480000 4.50
+ 0.204663500000 0.00
+ 0.204669480000 0.00
+ 0.204669500000 4.50
+ 0.206644980000 4.50
+ 0.206645000000 0.00
+ 0.206650980000 0.00
+ 0.206651000000 4.50
+ 0.208686480000 4.50
+ 0.208686500000 0.00
+ 0.208692480000 0.00
+ 0.208692500000 4.50
+ 0.210735480000 4.50
+ 0.210735500000 0.00
+ 0.210741480000 0.00
+ 0.210741500000 4.50
+ 0.212782980000 4.50
+ 0.212783000000 0.00
+ 0.212788980000 0.00
+ 0.212789000000 4.50
+ 0.214830980000 4.50
+ 0.214831000000 0.00
+ 0.214836980000 0.00
+ 0.214837000000 4.50
+ 0.216878480000 4.50
+ 0.216878500000 0.00
+ 0.216884480000 0.00
+ 0.216884500000 4.50
+ 0.218927980000 4.50
+ 0.218928000000 0.00
+ 0.218933980000 0.00
+ 0.218934000000 4.50
+ 0.220992480000 4.50
+ 0.220992500000 0.00
+ 0.220998480000 0.00
+ 0.220998500000 4.50
+ 0.223028480000 4.50
+ 0.223028500000 0.00
+ 0.223034480000 0.00
+ 0.223034500000 4.50
+ 0.225070480000 4.50
+ 0.225070500000 0.00
+ 0.225076480000 0.00
+ 0.225076500000 4.50
+ 0.227118980000 4.50
+ 0.227119000000 0.00
+ 0.227124980000 0.00
+ 0.227125000000 4.50
+ 0.229166980000 4.50
+ 0.229167000000 0.00
+ 0.229172980000 0.00
+ 0.229173000000 4.50
+ 0.231214480000 4.50
+ 0.231214500000 0.00
+ 0.231220480000 0.00
+ 0.231220500000 4.50
+ 0.233263980000 4.50
+ 0.233264000000 0.00
+ 0.233269980000 0.00
+ 0.233270000000 4.50
+ 0.235310480000 4.50
+ 0.235310500000 0.00
+ 0.235316480000 0.00
+ 0.235316500000 4.50
+ 0.237374980000 4.50
+ 0.237375000000 0.00
+ 0.237380980000 0.00
+ 0.237381000000 4.50
+ 0.239413480000 4.50
+ 0.239413500000 0.00
+ 0.239419480000 0.00
+ 0.239419500000 4.50
+ 0.241454480000 4.50
+ 0.241454500000 0.00
+ 0.241460480000 0.00
+ 0.241460500000 4.50
+ 0.243503980000 4.50
+ 0.243504000000 0.00
+ 0.243509980000 0.00
+ 0.243510000000 4.50
+ 0.245550980000 4.50
+ 0.245551000000 0.00
+ 0.245556980000 0.00
+ 0.245557000000 4.50
+ 0.247599480000 4.50
+ 0.247599500000 0.00
+ 0.247605480000 0.00
+ 0.247605500000 4.50
+ 0.249646480000 4.50
+ 0.249646500000 0.00
+ 0.249652480000 0.00
+ 0.249652500000 4.50
+ 0.251701480000 4.50
+ 0.251701500000 0.00
+ 0.251707480000 0.00
+ 0.251707500000 4.50
+ 0.253761980000 4.50
+ 0.253762000000 0.00
+ 0.253767980000 0.00
+ 0.253768000000 4.50
+ 0.255796480000 4.50
+ 0.255796500000 0.00
+ 0.255802480000 0.00
+ 0.255802500000 4.50
+ 0.257838980000 4.50
+ 0.257839000000 0.00
+ 0.257844980000 0.00
+ 0.257845000000 4.50
+ 0.259891480000 4.50
+ 0.259891500000 0.00
+ 0.259897480000 0.00
+ 0.259897500000 4.50
+ 0.261935980000 4.50
+ 0.261936000000 0.00
+ 0.261941980000 0.00
+ 0.261942000000 4.50
+ 0.263982480000 4.50
+ 0.263982500000 0.00
+ 0.263988480000 0.00
+ 0.263988500000 4.50
+ 0.266031480000 4.50
+ 0.266031500000 0.00
+ 0.266037480000 0.00
+ 0.266037500000 4.50
+ 0.268083480000 4.50
+ 0.268083500000 0.00
+ 0.268089480000 0.00
+ 0.268089500000 4.50
+ 0.270198980000 4.50
+ 0.270199000000 0.00
+ 0.270204980000 0.00
+ 0.270205000000 4.50
+ 0.272181980000 4.50
+ 0.272182000000 0.00
+ 0.272187980000 0.00
+ 0.272188000000 4.50
+ 0.274222980000 4.50
+ 0.274223000000 0.00
+ 0.274228980000 0.00
+ 0.274229000000 4.50
+ 0.276275980000 4.50
+ 0.276276000000 0.00
+ 0.276281980000 0.00
+ 0.276282000000 4.50
+ 0.278321480000 4.50
+ 0.278321500000 0.00
+ 0.278327480000 0.00
+ 0.278327500000 4.50
+ 0.280367480000 4.50
+ 0.280367500000 0.00
+ 0.280373480000 0.00
+ 0.280373500000 4.50
+ 0.282415980000 4.50
+ 0.282416000000 0.00
+ 0.282421980000 0.00
+ 0.282422000000 4.50
+ 0.284468480000 4.50
+ 0.284468500000 0.00
+ 0.284474480000 0.00
+ 0.284474500000 4.50
+ 0.286527980000 4.50
+ 0.286528000000 0.00
+ 0.286533980000 0.00
+ 0.286534000000 4.50
+ 0.288564980000 4.50
+ 0.288565000000 0.00
+ 0.288570980000 0.00
+ 0.288571000000 4.50
+ 0.290607980000 4.50
+ 0.290608000000 0.00
+ 0.290613980000 0.00
+ 0.290614000000 4.50
+ 0.292659480000 4.50
+ 0.292659500000 0.00
+ 0.292665480000 0.00
+ 0.292665500000 4.50
+ 0.294702980000 4.50
+ 0.294703000000 0.00
+ 0.294708980000 0.00
+ 0.294709000000 4.50
+ 0.296752980000 4.50
+ 0.296753000000 0.00
+ 0.296758980000 0.00
+ 0.296759000000 4.50
+ 0.298798980000 4.50
+ 0.298799000000 0.00
+ 0.298804980000 0.00
+ 0.298805000000 4.50
+ 0.300851980000 4.50
+ 0.300852000000 0.00
+ 0.300857980000 0.00
+ 0.300858000000 4.50
+ 0.302910980000 4.50
+ 0.302911000000 0.00
+ 0.302916980000 0.00
+ 0.302917000000 4.50
+ 0.304951480000 4.50
+ 0.304951500000 0.00
+ 0.304957480000 0.00
+ 0.304957500000 4.50
+ 0.306992480000 4.50
+ 0.306992500000 0.00
+ 0.306998480000 0.00
+ 0.306998500000 4.50
+ 0.309038980000 4.50
+ 0.309039000000 0.00
+ 0.309044980000 0.00
+ 0.309045000000 4.50
+ 0.311087980000 4.50
+ 0.311088000000 0.00
+ 0.311093980000 0.00
+ 0.311094000000 4.50
+ 0.313134980000 4.50
+ 0.313135000000 0.00
+ 0.313140980000 0.00
+ 0.313141000000 4.50
+ 0.315182480000 4.50
+ 0.315182500000 0.00
+ 0.315188480000 0.00
+ 0.315188500000 4.50
+ 0.317230480000 4.50
+ 0.317230500000 0.00
+ 0.317236480000 0.00
+ 0.317236500000 4.50
+ 0.319295980000 4.50
+ 0.319296000000 0.00
+ 0.319301980000 0.00
+ 0.319302000000 4.50
+ 0.321333480000 4.50
+ 0.321333500000 0.00
+ 0.321339480000 0.00
+ 0.321339500000 4.50
+ 0.323375980000 4.50
+ 0.323376000000 0.00
+ 0.323381980000 0.00
+ 0.323382000000 4.50
+ 0.325423480000 4.50
+ 0.325423500000 0.00
+ 0.325429480000 0.00
+ 0.325429500000 4.50
+ 0.327470980000 4.50
+ 0.327471000000 0.00
+ 0.327476980000 0.00
+ 0.327477000000 4.50
+ 0.329519980000 4.50
+ 0.329520000000 0.00
+ 0.329525980000 0.00
+ 0.329526000000 4.50
+ 0.331567480000 4.50
+ 0.331567500000 0.00
+ 0.331573480000 0.00
+ 0.331573500000 4.50
+ 0.333614980000 4.50
+ 0.333615000000 0.00
+ 0.333620980000 0.00
+ 0.333621000000 4.50
+ 0.335734980000 4.50
+ 0.335735000000 0.00
+ 0.335740980000 0.00
+ 0.335741000000 4.50
+ 0.337720480000 4.50
+ 0.337720500000 0.00
+ 0.337726480000 0.00
+ 0.337726500000 4.50
+ 0.339759480000 4.50
+ 0.339759500000 0.00
+ 0.339765480000 0.00
+ 0.339765500000 4.50
+ 0.341806480000 4.50
+ 0.341806500000 0.00
+ 0.341812480000 0.00
+ 0.341812500000 4.50
+ 0.343856980000 4.50
+ 0.343857000000 0.00
+ 0.343862980000 0.00
+ 0.343863000000 4.50
+ 0.345902980000 4.50
+ 0.345903000000 0.00
+ 0.345908980000 0.00
+ 0.345909000000 4.50
+ 0.347951980000 4.50
+ 0.347952000000 0.00
+ 0.347957980000 0.00
+ 0.347958000000 4.50
+ 0.349999980000 4.50
+ 0.350000000000 0.00
+ 0.350000020000 0.00
+ 0.370000000000 0.00
+ )
Vdriverow1 row1cmd 0 PWL(
+ 0.000000000000 4.50
+ 0.001840980000 4.50
+ 0.001841000000 0.00
+ 0.001846980000 0.00
+ 0.001847000000 4.50
+ 0.003888980000 4.50
+ 0.003889000000 0.00
+ 0.003894980000 0.00
+ 0.003895000000 4.50
+ 0.005934480000 4.50
+ 0.005934500000 0.00
+ 0.005940480000 0.00
+ 0.005940500000 4.50
+ 0.008054980000 4.50
+ 0.008055000000 0.00
+ 0.008060980000 0.00
+ 0.008061000000 4.50
+ 0.010041980000 4.50
+ 0.010042000000 0.00
+ 0.010047980000 0.00
+ 0.010048000000 4.50
+ 0.012078480000 4.50
+ 0.012078500000 0.00
+ 0.012084480000 0.00
+ 0.012084500000 4.50
+ 0.014126980000 4.50
+ 0.014127000000 0.00
+ 0.014132980000 0.00
+ 0.014133000000 4.50
+ 0.016175480000 4.50
+ 0.016175500000 0.00
+ 0.016181480000 0.00
+ 0.016181500000 4.50
+ 0.018227480000 4.50
+ 0.018227500000 0.00
+ 0.018233480000 0.00
+ 0.018233500000 4.50
+ 0.020271480000 4.50
+ 0.020271500000 0.00
+ 0.020277480000 0.00
+ 0.020277500000 4.50
+ 0.022318480000 4.50
+ 0.022318500000 0.00
+ 0.022324480000 0.00
+ 0.022324500000 4.50
+ 0.024383480000 4.50
+ 0.024383500000 0.00
+ 0.024389480000 0.00
+ 0.024389500000 4.50
+ 0.026425480000 4.50
+ 0.026425500000 0.00
+ 0.026431480000 0.00
+ 0.026431500000 4.50
+ 0.028462480000 4.50
+ 0.028462500000 0.00
+ 0.028468480000 0.00
+ 0.028468500000 4.50
+ 0.030511480000 4.50
+ 0.030511500000 0.00
+ 0.030517480000 0.00
+ 0.030517500000 4.50
+ 0.032559480000 4.50
+ 0.032559500000 0.00
+ 0.032565480000 0.00
+ 0.032565500000 4.50
+ 0.034610980000 4.50
+ 0.034611000000 0.00
+ 0.034616980000 0.00
+ 0.034617000000 4.50
+ 0.036654980000 4.50
+ 0.036655000000 0.00
+ 0.036660980000 0.00
+ 0.036661000000 4.50
+ 0.038703980000 4.50
+ 0.038704000000 0.00
+ 0.038709980000 0.00
+ 0.038710000000 4.50
+ 0.040766980000 4.50
+ 0.040767000000 0.00
+ 0.040772980000 0.00
+ 0.040773000000 4.50
+ 0.042812980000 4.50
+ 0.042813000000 0.00
+ 0.042818980000 0.00
+ 0.042819000000 4.50
+ 0.044846480000 4.50
+ 0.044846500000 0.00
+ 0.044852480000 0.00
+ 0.044852500000 4.50
+ 0.046895480000 4.50
+ 0.046895500000 0.00
+ 0.046901480000 0.00
+ 0.046901500000 4.50
+ 0.048943480000 4.50
+ 0.048943500000 0.00
+ 0.048949480000 0.00
+ 0.048949500000 4.50
+ 0.050995980000 4.50
+ 0.050996000000 0.00
+ 0.051001980000 0.00
+ 0.051002000000 4.50
+ 0.053039980000 4.50
+ 0.053040000000 0.00
+ 0.053045980000 0.00
+ 0.053046000000 4.50
+ 0.055088480000 4.50
+ 0.055088500000 0.00
+ 0.055094480000 0.00
+ 0.055094500000 4.50
+ 0.057151980000 4.50
+ 0.057152000000 0.00
+ 0.057157980000 0.00
+ 0.057158000000 4.50
+ 0.059196980000 4.50
+ 0.059197000000 0.00
+ 0.059202980000 0.00
+ 0.059203000000 4.50
+ 0.061233980000 4.50
+ 0.061234000000 0.00
+ 0.061239980000 0.00
+ 0.061240000000 4.50
+ 0.063279480000 4.50
+ 0.063279500000 0.00
+ 0.063285480000 0.00
+ 0.063285500000 4.50
+ 0.065326480000 4.50
+ 0.065326500000 0.00
+ 0.065332480000 0.00
+ 0.065332500000 4.50
+ 0.067375480000 4.50
+ 0.067375500000 0.00
+ 0.067381480000 0.00
+ 0.067381500000 4.50
+ 0.069422980000 4.50
+ 0.069423000000 0.00
+ 0.069428980000 0.00
+ 0.069429000000 4.50
+ 0.071471980000 4.50
+ 0.071472000000 0.00
+ 0.071477980000 0.00
+ 0.071478000000 4.50
+ 0.073590980000 4.50
+ 0.073591000000 0.00
+ 0.073596980000 0.00
+ 0.073597000000 4.50
+ 0.075573980000 4.50
+ 0.075574000000 0.00
+ 0.075579980000 0.00
+ 0.075580000000 4.50
+ 0.077614480000 4.50
+ 0.077614500000 0.00
+ 0.077620480000 0.00
+ 0.077620500000 4.50
+ 0.079663980000 4.50
+ 0.079664000000 0.00
+ 0.079669980000 0.00
+ 0.079670000000 4.50
+ 0.081710480000 4.50
+ 0.081710500000 0.00
+ 0.081716480000 0.00
+ 0.081716500000 4.50
+ 0.083759980000 4.50
+ 0.083760000000 0.00
+ 0.083765980000 0.00
+ 0.083766000000 4.50
+ 0.085806480000 4.50
+ 0.085806500000 0.00
+ 0.085812480000 0.00
+ 0.085812500000 4.50
+ 0.087854980000 4.50
+ 0.087855000000 0.00
+ 0.087860980000 0.00
+ 0.087861000000 4.50
+ 0.089919980000 4.50
+ 0.089920000000 0.00
+ 0.089925980000 0.00
+ 0.089926000000 4.50
+ 0.091956480000 4.50
+ 0.091956500000 0.00
+ 0.091962480000 0.00
+ 0.091962500000 4.50
+ 0.093998980000 4.50
+ 0.093999000000 0.00
+ 0.094004980000 0.00
+ 0.094005000000 4.50
+ 0.096051480000 4.50
+ 0.096051500000 0.00
+ 0.096057480000 0.00
+ 0.096057500000 4.50
+ 0.098096980000 4.50
+ 0.098097000000 0.00
+ 0.098102980000 0.00
+ 0.098103000000 4.50
+ 0.100143980000 4.50
+ 0.100144000000 0.00
+ 0.100149980000 0.00
+ 0.100150000000 4.50
+ 0.102190480000 4.50
+ 0.102190500000 0.00
+ 0.102196480000 0.00
+ 0.102196500000 4.50
+ 0.104240480000 4.50
+ 0.104240500000 0.00
+ 0.104246480000 0.00
+ 0.104246500000 4.50
+ 0.106304480000 4.50
+ 0.106304500000 0.00
+ 0.106310480000 0.00
+ 0.106310500000 4.50
+ 0.108343480000 4.50
+ 0.108343500000 0.00
+ 0.108349480000 0.00
+ 0.108349500000 4.50
+ 0.110383980000 4.50
+ 0.110384000000 0.00
+ 0.110389980000 0.00
+ 0.110390000000 4.50
+ 0.112430980000 4.50
+ 0.112431000000 0.00
+ 0.112436980000 0.00
+ 0.112437000000 4.50
+ 0.114479480000 4.50
+ 0.114479500000 0.00
+ 0.114485480000 0.00
+ 0.114485500000 4.50
+ 0.116526480000 4.50
+ 0.116526500000 0.00
+ 0.116532480000 0.00
+ 0.116532500000 4.50
+ 0.118574980000 4.50
+ 0.118575000000 0.00
+ 0.118580980000 0.00
+ 0.118581000000 4.50
+ 0.120623980000 4.50
+ 0.120624000000 0.00
+ 0.120629980000 0.00
+ 0.120630000000 4.50
+ 0.122686980000 4.50
+ 0.122687000000 0.00
+ 0.122692980000 0.00
+ 0.122693000000 4.50
+ 0.124724980000 4.50
+ 0.124725000000 0.00
+ 0.124730980000 0.00
+ 0.124731000000 4.50
+ 0.126771980000 4.50
+ 0.126772000000 0.00
+ 0.126777980000 0.00
+ 0.126778000000 4.50
+ 0.128815980000 4.50
+ 0.128816000000 0.00
+ 0.128821980000 0.00
+ 0.128822000000 4.50
+ 0.130863480000 4.50
+ 0.130863500000 0.00
+ 0.130869480000 0.00
+ 0.130869500000 4.50
+ 0.132911480000 4.50
+ 0.132911500000 0.00
+ 0.132917480000 0.00
+ 0.132917500000 4.50
+ 0.134963480000 4.50
+ 0.134963500000 0.00
+ 0.134969480000 0.00
+ 0.134969500000 4.50
+ 0.137006480000 4.50
+ 0.137006500000 0.00
+ 0.137012480000 0.00
+ 0.137012500000 4.50
+ 0.139126980000 4.50
+ 0.139127000000 0.00
+ 0.139132980000 0.00
+ 0.139133000000 4.50
+ 0.141109980000 4.50
+ 0.141110000000 0.00
+ 0.141115980000 0.00
+ 0.141116000000 4.50
+ 0.143155480000 4.50
+ 0.143155500000 0.00
+ 0.143161480000 0.00
+ 0.143161500000 4.50
+ 0.145198480000 4.50
+ 0.145198500000 0.00
+ 0.145204480000 0.00
+ 0.145204500000 4.50
+ 0.147247480000 4.50
+ 0.147247500000 0.00
+ 0.147253480000 0.00
+ 0.147253500000 4.50
+ 0.149294480000 4.50
+ 0.149294500000 0.00
+ 0.149300480000 0.00
+ 0.149300500000 4.50
+ 0.151349980000 4.50
+ 0.151350000000 0.00
+ 0.151355980000 0.00
+ 0.151356000000 4.50
+ 0.153392980000 4.50
+ 0.153393000000 0.00
+ 0.153398980000 0.00
+ 0.153399000000 4.50
+ 0.155455980000 4.50
+ 0.155456000000 0.00
+ 0.155461980000 0.00
+ 0.155462000000 4.50
+ 0.157492980000 4.50
+ 0.157493000000 0.00
+ 0.157498980000 0.00
+ 0.157499000000 4.50
+ 0.159539480000 4.50
+ 0.159539500000 0.00
+ 0.159545480000 0.00
+ 0.159545500000 4.50
+ 0.161582480000 4.50
+ 0.161582500000 0.00
+ 0.161588480000 0.00
+ 0.161588500000 4.50
+ 0.163630480000 4.50
+ 0.163630500000 0.00
+ 0.163636480000 0.00
+ 0.163636500000 4.50
+ 0.165682980000 4.50
+ 0.165683000000 0.00
+ 0.165688980000 0.00
+ 0.165689000000 4.50
+ 0.167731480000 4.50
+ 0.167731500000 0.00
+ 0.167737480000 0.00
+ 0.167737500000 4.50
+ 0.169775480000 4.50
+ 0.169775500000 0.00
+ 0.169781480000 0.00
+ 0.169781500000 4.50
+ 0.171839480000 4.50
+ 0.171839500000 0.00
+ 0.171845480000 0.00
+ 0.171845500000 4.50
+ 0.173878980000 4.50
+ 0.173879000000 0.00
+ 0.173884980000 0.00
+ 0.173885000000 4.50
+ 0.175923980000 4.50
+ 0.175924000000 0.00
+ 0.175929980000 0.00
+ 0.175930000000 4.50
+ 0.177970980000 4.50
+ 0.177971000000 0.00
+ 0.177976980000 0.00
+ 0.177977000000 4.50
+ 0.180014480000 4.50
+ 0.180014500000 0.00
+ 0.180020480000 0.00
+ 0.180020500000 4.50
+ 0.182063480000 4.50
+ 0.182063500000 0.00
+ 0.182069480000 0.00
+ 0.182069500000 4.50
+ 0.184114980000 4.50
+ 0.184115000000 0.00
+ 0.184120980000 0.00
+ 0.184121000000 4.50
+ 0.186158980000 4.50
+ 0.186159000000 0.00
+ 0.186164980000 0.00
+ 0.186165000000 4.50
+ 0.188223480000 4.50
+ 0.188223500000 0.00
+ 0.188229480000 0.00
+ 0.188229500000 4.50
+ 0.190260480000 4.50
+ 0.190260500000 0.00
+ 0.190266480000 0.00
+ 0.190266500000 4.50
+ 0.192306480000 4.50
+ 0.192306500000 0.00
+ 0.192312480000 0.00
+ 0.192312500000 4.50
+ 0.194350980000 4.50
+ 0.194351000000 0.00
+ 0.194356980000 0.00
+ 0.194357000000 4.50
+ 0.196398980000 4.50
+ 0.196399000000 0.00
+ 0.196404980000 0.00
+ 0.196405000000 4.50
+ 0.198446480000 4.50
+ 0.198446500000 0.00
+ 0.198452480000 0.00
+ 0.198452500000 4.50
+ 0.200494480000 4.50
+ 0.200494500000 0.00
+ 0.200500480000 0.00
+ 0.200500500000 4.50
+ 0.202543480000 4.50
+ 0.202543500000 0.00
+ 0.202549480000 0.00
+ 0.202549500000 4.50
+ 0.204663480000 4.50
+ 0.204663500000 0.00
+ 0.204669480000 0.00
+ 0.204669500000 4.50
+ 0.206644980000 4.50
+ 0.206645000000 0.00
+ 0.206650980000 0.00
+ 0.206651000000 4.50
+ 0.208686480000 4.50
+ 0.208686500000 0.00
+ 0.208692480000 0.00
+ 0.208692500000 4.50
+ 0.210735480000 4.50
+ 0.210735500000 0.00
+ 0.210741480000 0.00
+ 0.210741500000 4.50
+ 0.212782980000 4.50
+ 0.212783000000 0.00
+ 0.212788980000 0.00
+ 0.212789000000 4.50
+ 0.214830980000 4.50
+ 0.214831000000 0.00
+ 0.214836980000 0.00
+ 0.214837000000 4.50
+ 0.216878480000 4.50
+ 0.216878500000 0.00
+ 0.216884480000 0.00
+ 0.216884500000 4.50
+ 0.218927980000 4.50
+ 0.218928000000 0.00
+ 0.218933980000 0.00
+ 0.218934000000 4.50
+ 0.220992480000 4.50
+ 0.220992500000 0.00
+ 0.220998480000 0.00
+ 0.220998500000 4.50
+ 0.223028480000 4.50
+ 0.223028500000 0.00
+ 0.223034480000 0.00
+ 0.223034500000 4.50
+ 0.225070480000 4.50
+ 0.225070500000 0.00
+ 0.225076480000 0.00
+ 0.225076500000 4.50
+ 0.227118980000 4.50
+ 0.227119000000 0.00
+ 0.227124980000 0.00
+ 0.227125000000 4.50
+ 0.229166980000 4.50
+ 0.229167000000 0.00
+ 0.229172980000 0.00
+ 0.229173000000 4.50
+ 0.231214480000 4.50
+ 0.231214500000 0.00
+ 0.231220480000 0.00
+ 0.231220500000 4.50
+ 0.233263980000 4.50
+ 0.233264000000 0.00
+ 0.233269980000 0.00
+ 0.233270000000 4.50
+ 0.235310480000 4.50
+ 0.235310500000 0.00
+ 0.235316480000 0.00
+ 0.235316500000 4.50
+ 0.237374980000 4.50
+ 0.237375000000 0.00
+ 0.237380980000 0.00
+ 0.237381000000 4.50
+ 0.239413480000 4.50
+ 0.239413500000 0.00
+ 0.239419480000 0.00
+ 0.239419500000 4.50
+ 0.241454480000 4.50
+ 0.241454500000 0.00
+ 0.241460480000 0.00
+ 0.241460500000 4.50
+ 0.243503980000 4.50
+ 0.243504000000 0.00
+ 0.243509980000 0.00
+ 0.243510000000 4.50
+ 0.245550980000 4.50
+ 0.245551000000 0.00
+ 0.245556980000 0.00
+ 0.245557000000 4.50
+ 0.247599480000 4.50
+ 0.247599500000 0.00
+ 0.247605480000 0.00
+ 0.247605500000 4.50
+ 0.249646480000 4.50
+ 0.249646500000 0.00
+ 0.249652480000 0.00
+ 0.249652500000 4.50
+ 0.251701480000 4.50
+ 0.251701500000 0.00
+ 0.251707480000 0.00
+ 0.251707500000 4.50
+ 0.253761980000 4.50
+ 0.253762000000 0.00
+ 0.253767980000 0.00
+ 0.253768000000 4.50
+ 0.255796480000 4.50
+ 0.255796500000 0.00
+ 0.255802480000 0.00
+ 0.255802500000 4.50
+ 0.257838980000 4.50
+ 0.257839000000 0.00
+ 0.257844980000 0.00
+ 0.257845000000 4.50
+ 0.259891480000 4.50
+ 0.259891500000 0.00
+ 0.259897480000 0.00
+ 0.259897500000 4.50
+ 0.261935980000 4.50
+ 0.261936000000 0.00
+ 0.261941980000 0.00
+ 0.261942000000 4.50
+ 0.263982480000 4.50
+ 0.263982500000 0.00
+ 0.263988480000 0.00
+ 0.263988500000 4.50
+ 0.266031480000 4.50
+ 0.266031500000 0.00
+ 0.266037480000 0.00
+ 0.266037500000 4.50
+ 0.268083480000 4.50
+ 0.268083500000 0.00
+ 0.268089480000 0.00
+ 0.268089500000 4.50
+ 0.270198980000 4.50
+ 0.270199000000 0.00
+ 0.270204980000 0.00
+ 0.270205000000 4.50
+ 0.272181980000 4.50
+ 0.272182000000 0.00
+ 0.272187980000 0.00
+ 0.272188000000 4.50
+ 0.274222980000 4.50
+ 0.274223000000 0.00
+ 0.274228980000 0.00
+ 0.274229000000 4.50
+ 0.276275980000 4.50
+ 0.276276000000 0.00
+ 0.276281980000 0.00
+ 0.276282000000 4.50
+ 0.278321480000 4.50
+ 0.278321500000 0.00
+ 0.278327480000 0.00
+ 0.278327500000 4.50
+ 0.280367480000 4.50
+ 0.280367500000 0.00
+ 0.280373480000 0.00
+ 0.280373500000 4.50
+ 0.282415980000 4.50
+ 0.282416000000 0.00
+ 0.282421980000 0.00
+ 0.282422000000 4.50
+ 0.284468480000 4.50
+ 0.284468500000 0.00
+ 0.284474480000 0.00
+ 0.284474500000 4.50
+ 0.286527980000 4.50
+ 0.286528000000 0.00
+ 0.286533980000 0.00
+ 0.286534000000 4.50
+ 0.288564980000 4.50
+ 0.288565000000 0.00
+ 0.288570980000 0.00
+ 0.288571000000 4.50
+ 0.290607980000 4.50
+ 0.290608000000 0.00
+ 0.290613980000 0.00
+ 0.290614000000 4.50
+ 0.292659480000 4.50
+ 0.292659500000 0.00
+ 0.292665480000 0.00
+ 0.292665500000 4.50
+ 0.294702980000 4.50
+ 0.294703000000 0.00
+ 0.294708980000 0.00
+ 0.294709000000 4.50
+ 0.296752980000 4.50
+ 0.296753000000 0.00
+ 0.296758980000 0.00
+ 0.296759000000 4.50
+ 0.298798980000 4.50
+ 0.298799000000 0.00
+ 0.298804980000 0.00
+ 0.298805000000 4.50
+ 0.300851980000 4.50
+ 0.300852000000 0.00
+ 0.300857980000 0.00
+ 0.300858000000 4.50
+ 0.302910980000 4.50
+ 0.302911000000 0.00
+ 0.302916980000 0.00
+ 0.302917000000 4.50
+ 0.304951480000 4.50
+ 0.304951500000 0.00
+ 0.304957480000 0.00
+ 0.304957500000 4.50
+ 0.306992480000 4.50
+ 0.306992500000 0.00
+ 0.306998480000 0.00
+ 0.306998500000 4.50
+ 0.309038980000 4.50
+ 0.309039000000 0.00
+ 0.309044980000 0.00
+ 0.309045000000 4.50
+ 0.311087980000 4.50
+ 0.311088000000 0.00
+ 0.311093980000 0.00
+ 0.311094000000 4.50
+ 0.313134980000 4.50
+ 0.313135000000 0.00
+ 0.313140980000 0.00
+ 0.313141000000 4.50
+ 0.315182480000 4.50
+ 0.315182500000 0.00
+ 0.315188480000 0.00
+ 0.315188500000 4.50
+ 0.317230480000 4.50
+ 0.317230500000 0.00
+ 0.317236480000 0.00
+ 0.317236500000 4.50
+ 0.319295980000 4.50
+ 0.319296000000 0.00
+ 0.319301980000 0.00
+ 0.319302000000 4.50
+ 0.321333480000 4.50
+ 0.321333500000 0.00
+ 0.321339480000 0.00
+ 0.321339500000 4.50
+ 0.323375980000 4.50
+ 0.323376000000 0.00
+ 0.323381980000 0.00
+ 0.323382000000 4.50
+ 0.325423480000 4.50
+ 0.325423500000 0.00
+ 0.325429480000 0.00
+ 0.325429500000 4.50
+ 0.327470980000 4.50
+ 0.327471000000 0.00
+ 0.327476980000 0.00
+ 0.327477000000 4.50
+ 0.329519980000 4.50
+ 0.329520000000 0.00
+ 0.329525980000 0.00
+ 0.329526000000 4.50
+ 0.331567480000 4.50
+ 0.331567500000 0.00
+ 0.331573480000 0.00
+ 0.331573500000 4.50
+ 0.333614980000 4.50
+ 0.333615000000 0.00
+ 0.333620980000 0.00
+ 0.333621000000 4.50
+ 0.335734980000 4.50
+ 0.335735000000 0.00
+ 0.335740980000 0.00
+ 0.335741000000 4.50
+ 0.337720480000 4.50
+ 0.337720500000 0.00
+ 0.337726480000 0.00
+ 0.337726500000 4.50
+ 0.339759480000 4.50
+ 0.339759500000 0.00
+ 0.339765480000 0.00
+ 0.339765500000 4.50
+ 0.341806480000 4.50
+ 0.341806500000 0.00
+ 0.341812480000 0.00
+ 0.341812500000 4.50
+ 0.343856980000 4.50
+ 0.343857000000 0.00
+ 0.343862980000 0.00
+ 0.343863000000 4.50
+ 0.345902980000 4.50
+ 0.345903000000 0.00
+ 0.345908980000 0.00
+ 0.345909000000 4.50
+ 0.347951980000 4.50
+ 0.347952000000 0.00
+ 0.347957980000 0.00
+ 0.347958000000 4.50
+ 0.349999980000 4.50
+ 0.350000000000 0.00
+ 0.350000020000 0.00
+ 0.370000000000 0.00
+ )
Vdriverow2 row2cmd 0 PWL(
+ 0.000000000000 4.50
+ 0.001840980000 4.50
+ 0.001841000000 0.00
+ 0.001846980000 0.00
+ 0.001847000000 4.50
+ 0.003888980000 4.50
+ 0.003889000000 0.00
+ 0.003894980000 0.00
+ 0.003895000000 4.50
+ 0.005934480000 4.50
+ 0.005934500000 0.00
+ 0.005940480000 0.00
+ 0.005940500000 4.50
+ 0.008054980000 4.50
+ 0.008055000000 0.00
+ 0.008060980000 0.00
+ 0.008061000000 4.50
+ 0.010041980000 4.50
+ 0.010042000000 0.00
+ 0.010047980000 0.00
+ 0.010048000000 4.50
+ 0.012078480000 4.50
+ 0.012078500000 0.00
+ 0.012084480000 0.00
+ 0.012084500000 4.50
+ 0.014126980000 4.50
+ 0.014127000000 0.00
+ 0.014132980000 0.00
+ 0.014133000000 4.50
+ 0.016175480000 4.50
+ 0.016175500000 0.00
+ 0.016181480000 0.00
+ 0.016181500000 4.50
+ 0.018227480000 4.50
+ 0.018227500000 0.00
+ 0.018233480000 0.00
+ 0.018233500000 4.50
+ 0.020271480000 4.50
+ 0.020271500000 0.00
+ 0.020277480000 0.00
+ 0.020277500000 4.50
+ 0.022318480000 4.50
+ 0.022318500000 0.00
+ 0.022324480000 0.00
+ 0.022324500000 4.50
+ 0.024383480000 4.50
+ 0.024383500000 0.00
+ 0.024389480000 0.00
+ 0.024389500000 4.50
+ 0.026425480000 4.50
+ 0.026425500000 0.00
+ 0.026431480000 0.00
+ 0.026431500000 4.50
+ 0.028462480000 4.50
+ 0.028462500000 0.00
+ 0.028468480000 0.00
+ 0.028468500000 4.50
+ 0.030511480000 4.50
+ 0.030511500000 0.00
+ 0.030517480000 0.00
+ 0.030517500000 4.50
+ 0.032559480000 4.50
+ 0.032559500000 0.00
+ 0.032565480000 0.00
+ 0.032565500000 4.50
+ 0.034610980000 4.50
+ 0.034611000000 0.00
+ 0.034616980000 0.00
+ 0.034617000000 4.50
+ 0.036654980000 4.50
+ 0.036655000000 0.00
+ 0.036660980000 0.00
+ 0.036661000000 4.50
+ 0.038703980000 4.50
+ 0.038704000000 0.00
+ 0.038709980000 0.00
+ 0.038710000000 4.50
+ 0.040766980000 4.50
+ 0.040767000000 0.00
+ 0.040772980000 0.00
+ 0.040773000000 4.50
+ 0.042812980000 4.50
+ 0.042813000000 0.00
+ 0.042818980000 0.00
+ 0.042819000000 4.50
+ 0.044846480000 4.50
+ 0.044846500000 0.00
+ 0.044852480000 0.00
+ 0.044852500000 4.50
+ 0.046895480000 4.50
+ 0.046895500000 0.00
+ 0.046901480000 0.00
+ 0.046901500000 4.50
+ 0.048943480000 4.50
+ 0.048943500000 0.00
+ 0.048949480000 0.00
+ 0.048949500000 4.50
+ 0.050995980000 4.50
+ 0.050996000000 0.00
+ 0.051001980000 0.00
+ 0.051002000000 4.50
+ 0.053039980000 4.50
+ 0.053040000000 0.00
+ 0.053045980000 0.00
+ 0.053046000000 4.50
+ 0.055088480000 4.50
+ 0.055088500000 0.00
+ 0.055094480000 0.00
+ 0.055094500000 4.50
+ 0.057151980000 4.50
+ 0.057152000000 0.00
+ 0.057157980000 0.00
+ 0.057158000000 4.50
+ 0.059196980000 4.50
+ 0.059197000000 0.00
+ 0.059202980000 0.00
+ 0.059203000000 4.50
+ 0.061233980000 4.50
+ 0.061234000000 0.00
+ 0.061239980000 0.00
+ 0.061240000000 4.50
+ 0.063279480000 4.50
+ 0.063279500000 0.00
+ 0.063285480000 0.00
+ 0.063285500000 4.50
+ 0.065326480000 4.50
+ 0.065326500000 0.00
+ 0.065332480000 0.00
+ 0.065332500000 4.50
+ 0.067375480000 4.50
+ 0.067375500000 0.00
+ 0.067381480000 0.00
+ 0.067381500000 4.50
+ 0.069422980000 4.50
+ 0.069423000000 0.00
+ 0.069428980000 0.00
+ 0.069429000000 4.50
+ 0.071471980000 4.50
+ 0.071472000000 0.00
+ 0.071477980000 0.00
+ 0.071478000000 4.50
+ 0.073590980000 4.50
+ 0.073591000000 0.00
+ 0.073596980000 0.00
+ 0.073597000000 4.50
+ 0.075573980000 4.50
+ 0.075574000000 0.00
+ 0.075579980000 0.00
+ 0.075580000000 4.50
+ 0.077614480000 4.50
+ 0.077614500000 0.00
+ 0.077620480000 0.00
+ 0.077620500000 4.50
+ 0.079663980000 4.50
+ 0.079664000000 0.00
+ 0.079669980000 0.00
+ 0.079670000000 4.50
+ 0.081710480000 4.50
+ 0.081710500000 0.00
+ 0.081716480000 0.00
+ 0.081716500000 4.50
+ 0.083759980000 4.50
+ 0.083760000000 0.00
+ 0.083765980000 0.00
+ 0.083766000000 4.50
+ 0.085806480000 4.50
+ 0.085806500000 0.00
+ 0.085812480000 0.00
+ 0.085812500000 4.50
+ 0.087854980000 4.50
+ 0.087855000000 0.00
+ 0.087860980000 0.00
+ 0.087861000000 4.50
+ 0.089919980000 4.50
+ 0.089920000000 0.00
+ 0.089925980000 0.00
+ 0.089926000000 4.50
+ 0.091956480000 4.50
+ 0.091956500000 0.00
+ 0.091962480000 0.00
+ 0.091962500000 4.50
+ 0.093998980000 4.50
+ 0.093999000000 0.00
+ 0.094004980000 0.00
+ 0.094005000000 4.50
+ 0.096051480000 4.50
+ 0.096051500000 0.00
+ 0.096057480000 0.00
+ 0.096057500000 4.50
+ 0.098096980000 4.50
+ 0.098097000000 0.00
+ 0.098102980000 0.00
+ 0.098103000000 4.50
+ 0.100143980000 4.50
+ 0.100144000000 0.00
+ 0.100149980000 0.00
+ 0.100150000000 4.50
+ 0.102190480000 4.50
+ 0.102190500000 0.00
+ 0.102196480000 0.00
+ 0.102196500000 4.50
+ 0.104240480000 4.50
+ 0.104240500000 0.00
+ 0.104246480000 0.00
+ 0.104246500000 4.50
+ 0.106304480000 4.50
+ 0.106304500000 0.00
+ 0.106310480000 0.00
+ 0.106310500000 4.50
+ 0.108343480000 4.50
+ 0.108343500000 0.00
+ 0.108349480000 0.00
+ 0.108349500000 4.50
+ 0.110383980000 4.50
+ 0.110384000000 0.00
+ 0.110389980000 0.00
+ 0.110390000000 4.50
+ 0.112430980000 4.50
+ 0.112431000000 0.00
+ 0.112436980000 0.00
+ 0.112437000000 4.50
+ 0.114479480000 4.50
+ 0.114479500000 0.00
+ 0.114485480000 0.00
+ 0.114485500000 4.50
+ 0.116526480000 4.50
+ 0.116526500000 0.00
+ 0.116532480000 0.00
+ 0.116532500000 4.50
+ 0.118574980000 4.50
+ 0.118575000000 0.00
+ 0.118580980000 0.00
+ 0.118581000000 4.50
+ 0.120623980000 4.50
+ 0.120624000000 0.00
+ 0.120629980000 0.00
+ 0.120630000000 4.50
+ 0.122686980000 4.50
+ 0.122687000000 0.00
+ 0.122692980000 0.00
+ 0.122693000000 4.50
+ 0.124724980000 4.50
+ 0.124725000000 0.00
+ 0.124730980000 0.00
+ 0.124731000000 4.50
+ 0.126771980000 4.50
+ 0.126772000000 0.00
+ 0.126777980000 0.00
+ 0.126778000000 4.50
+ 0.128815980000 4.50
+ 0.128816000000 0.00
+ 0.128821980000 0.00
+ 0.128822000000 4.50
+ 0.130863480000 4.50
+ 0.130863500000 0.00
+ 0.130869480000 0.00
+ 0.130869500000 4.50
+ 0.132911480000 4.50
+ 0.132911500000 0.00
+ 0.132917480000 0.00
+ 0.132917500000 4.50
+ 0.134963480000 4.50
+ 0.134963500000 0.00
+ 0.134969480000 0.00
+ 0.134969500000 4.50
+ 0.137006480000 4.50
+ 0.137006500000 0.00
+ 0.137012480000 0.00
+ 0.137012500000 4.50
+ 0.139126980000 4.50
+ 0.139127000000 0.00
+ 0.139132980000 0.00
+ 0.139133000000 4.50
+ 0.141109980000 4.50
+ 0.141110000000 0.00
+ 0.141115980000 0.00
+ 0.141116000000 4.50
+ 0.143155480000 4.50
+ 0.143155500000 0.00
+ 0.143161480000 0.00
+ 0.143161500000 4.50
+ 0.145198480000 4.50
+ 0.145198500000 0.00
+ 0.145204480000 0.00
+ 0.145204500000 4.50
+ 0.147247480000 4.50
+ 0.147247500000 0.00
+ 0.147253480000 0.00
+ 0.147253500000 4.50
+ 0.149294480000 4.50
+ 0.149294500000 0.00
+ 0.149300480000 0.00
+ 0.149300500000 4.50
+ 0.151349980000 4.50
+ 0.151350000000 0.00
+ 0.151355980000 0.00
+ 0.151356000000 4.50
+ 0.153392980000 4.50
+ 0.153393000000 0.00
+ 0.153398980000 0.00
+ 0.153399000000 4.50
+ 0.155455980000 4.50
+ 0.155456000000 0.00
+ 0.155461980000 0.00
+ 0.155462000000 4.50
+ 0.157492980000 4.50
+ 0.157493000000 0.00
+ 0.157498980000 0.00
+ 0.157499000000 4.50
+ 0.159539480000 4.50
+ 0.159539500000 0.00
+ 0.159545480000 0.00
+ 0.159545500000 4.50
+ 0.161582480000 4.50
+ 0.161582500000 0.00
+ 0.161588480000 0.00
+ 0.161588500000 4.50
+ 0.163630480000 4.50
+ 0.163630500000 0.00
+ 0.163636480000 0.00
+ 0.163636500000 4.50
+ 0.165682980000 4.50
+ 0.165683000000 0.00
+ 0.165688980000 0.00
+ 0.165689000000 4.50
+ 0.167731480000 4.50
+ 0.167731500000 0.00
+ 0.167737480000 0.00
+ 0.167737500000 4.50
+ 0.169775480000 4.50
+ 0.169775500000 0.00
+ 0.169781480000 0.00
+ 0.169781500000 4.50
+ 0.171839480000 4.50
+ 0.171839500000 0.00
+ 0.171845480000 0.00
+ 0.171845500000 4.50
+ 0.173878980000 4.50
+ 0.173879000000 0.00
+ 0.173884980000 0.00
+ 0.173885000000 4.50
+ 0.175923980000 4.50
+ 0.175924000000 0.00
+ 0.175929980000 0.00
+ 0.175930000000 4.50
+ 0.177970980000 4.50
+ 0.177971000000 0.00
+ 0.177976980000 0.00
+ 0.177977000000 4.50
+ 0.180014480000 4.50
+ 0.180014500000 0.00
+ 0.180020480000 0.00
+ 0.180020500000 4.50
+ 0.182063480000 4.50
+ 0.182063500000 0.00
+ 0.182069480000 0.00
+ 0.182069500000 4.50
+ 0.184114980000 4.50
+ 0.184115000000 0.00
+ 0.184120980000 0.00
+ 0.184121000000 4.50
+ 0.186158980000 4.50
+ 0.186159000000 0.00
+ 0.186164980000 0.00
+ 0.186165000000 4.50
+ 0.188223480000 4.50
+ 0.188223500000 0.00
+ 0.188229480000 0.00
+ 0.188229500000 4.50
+ 0.190260480000 4.50
+ 0.190260500000 0.00
+ 0.190266480000 0.00
+ 0.190266500000 4.50
+ 0.192306480000 4.50
+ 0.192306500000 0.00
+ 0.192312480000 0.00
+ 0.192312500000 4.50
+ 0.194350980000 4.50
+ 0.194351000000 0.00
+ 0.194356980000 0.00
+ 0.194357000000 4.50
+ 0.196398980000 4.50
+ 0.196399000000 0.00
+ 0.196404980000 0.00
+ 0.196405000000 4.50
+ 0.198446480000 4.50
+ 0.198446500000 0.00
+ 0.198452480000 0.00
+ 0.198452500000 4.50
+ 0.200494480000 4.50
+ 0.200494500000 0.00
+ 0.200500480000 0.00
+ 0.200500500000 4.50
+ 0.202543480000 4.50
+ 0.202543500000 0.00
+ 0.202549480000 0.00
+ 0.202549500000 4.50
+ 0.204663480000 4.50
+ 0.204663500000 0.00
+ 0.204669480000 0.00
+ 0.204669500000 4.50
+ 0.206644980000 4.50
+ 0.206645000000 0.00
+ 0.206650980000 0.00
+ 0.206651000000 4.50
+ 0.208686480000 4.50
+ 0.208686500000 0.00
+ 0.208692480000 0.00
+ 0.208692500000 4.50
+ 0.210735480000 4.50
+ 0.210735500000 0.00
+ 0.210741480000 0.00
+ 0.210741500000 4.50
+ 0.212782980000 4.50
+ 0.212783000000 0.00
+ 0.212788980000 0.00
+ 0.212789000000 4.50
+ 0.214830980000 4.50
+ 0.214831000000 0.00
+ 0.214836980000 0.00
+ 0.214837000000 4.50
+ 0.216878480000 4.50
+ 0.216878500000 0.00
+ 0.216884480000 0.00
+ 0.216884500000 4.50
+ 0.218927980000 4.50
+ 0.218928000000 0.00
+ 0.218933980000 0.00
+ 0.218934000000 4.50
+ 0.220992480000 4.50
+ 0.220992500000 0.00
+ 0.220998480000 0.00
+ 0.220998500000 4.50
+ 0.223028480000 4.50
+ 0.223028500000 0.00
+ 0.223034480000 0.00
+ 0.223034500000 4.50
+ 0.225070480000 4.50
+ 0.225070500000 0.00
+ 0.225076480000 0.00
+ 0.225076500000 4.50
+ 0.227118980000 4.50
+ 0.227119000000 0.00
+ 0.227124980000 0.00
+ 0.227125000000 4.50
+ 0.229166980000 4.50
+ 0.229167000000 0.00
+ 0.229172980000 0.00
+ 0.229173000000 4.50
+ 0.231214480000 4.50
+ 0.231214500000 0.00
+ 0.231220480000 0.00
+ 0.231220500000 4.50
+ 0.233263980000 4.50
+ 0.233264000000 0.00
+ 0.233269980000 0.00
+ 0.233270000000 4.50
+ 0.235310480000 4.50
+ 0.235310500000 0.00
+ 0.235316480000 0.00
+ 0.235316500000 4.50
+ 0.237374980000 4.50
+ 0.237375000000 0.00
+ 0.237380980000 0.00
+ 0.237381000000 4.50
+ 0.239413480000 4.50
+ 0.239413500000 0.00
+ 0.239419480000 0.00
+ 0.239419500000 4.50
+ 0.241454480000 4.50
+ 0.241454500000 0.00
+ 0.241460480000 0.00
+ 0.241460500000 4.50
+ 0.243503980000 4.50
+ 0.243504000000 0.00
+ 0.243509980000 0.00
+ 0.243510000000 4.50
+ 0.245550980000 4.50
+ 0.245551000000 0.00
+ 0.245556980000 0.00
+ 0.245557000000 4.50
+ 0.247599480000 4.50
+ 0.247599500000 0.00
+ 0.247605480000 0.00
+ 0.247605500000 4.50
+ 0.249646480000 4.50
+ 0.249646500000 0.00
+ 0.249652480000 0.00
+ 0.249652500000 4.50
+ 0.251701480000 4.50
+ 0.251701500000 0.00
+ 0.251707480000 0.00
+ 0.251707500000 4.50
+ 0.253761980000 4.50
+ 0.253762000000 0.00
+ 0.253767980000 0.00
+ 0.253768000000 4.50
+ 0.255796480000 4.50
+ 0.255796500000 0.00
+ 0.255802480000 0.00
+ 0.255802500000 4.50
+ 0.257838980000 4.50
+ 0.257839000000 0.00
+ 0.257844980000 0.00
+ 0.257845000000 4.50
+ 0.259891480000 4.50
+ 0.259891500000 0.00
+ 0.259897480000 0.00
+ 0.259897500000 4.50
+ 0.261935980000 4.50
+ 0.261936000000 0.00
+ 0.261941980000 0.00
+ 0.261942000000 4.50
+ 0.263982480000 4.50
+ 0.263982500000 0.00
+ 0.263988480000 0.00
+ 0.263988500000 4.50
+ 0.266031480000 4.50
+ 0.266031500000 0.00
+ 0.266037480000 0.00
+ 0.266037500000 4.50
+ 0.268083480000 4.50
+ 0.268083500000 0.00
+ 0.268089480000 0.00
+ 0.268089500000 4.50
+ 0.270198980000 4.50
+ 0.270199000000 0.00
+ 0.270204980000 0.00
+ 0.270205000000 4.50
+ 0.272181980000 4.50
+ 0.272182000000 0.00
+ 0.272187980000 0.00
+ 0.272188000000 4.50
+ 0.274222980000 4.50
+ 0.274223000000 0.00
+ 0.274228980000 0.00
+ 0.274229000000 4.50
+ 0.276275980000 4.50
+ 0.276276000000 0.00
+ 0.276281980000 0.00
+ 0.276282000000 4.50
+ 0.278321480000 4.50
+ 0.278321500000 0.00
+ 0.278327480000 0.00
+ 0.278327500000 4.50
+ 0.280367480000 4.50
+ 0.280367500000 0.00
+ 0.280373480000 0.00
+ 0.280373500000 4.50
+ 0.282415980000 4.50
+ 0.282416000000 0.00
+ 0.282421980000 0.00
+ 0.282422000000 4.50
+ 0.284468480000 4.50
+ 0.284468500000 0.00
+ 0.284474480000 0.00
+ 0.284474500000 4.50
+ 0.286527980000 4.50
+ 0.286528000000 0.00
+ 0.286533980000 0.00
+ 0.286534000000 4.50
+ 0.288564980000 4.50
+ 0.288565000000 0.00
+ 0.288570980000 0.00
+ 0.288571000000 4.50
+ 0.290607980000 4.50
+ 0.290608000000 0.00
+ 0.290613980000 0.00
+ 0.290614000000 4.50
+ 0.292659480000 4.50
+ 0.292659500000 0.00
+ 0.292665480000 0.00
+ 0.292665500000 4.50
+ 0.294702980000 4.50
+ 0.294703000000 0.00
+ 0.294708980000 0.00
+ 0.294709000000 4.50
+ 0.296752980000 4.50
+ 0.296753000000 0.00
+ 0.296758980000 0.00
+ 0.296759000000 4.50
+ 0.298798980000 4.50
+ 0.298799000000 0.00
+ 0.298804980000 0.00
+ 0.298805000000 4.50
+ 0.300851980000 4.50
+ 0.300852000000 0.00
+ 0.300857980000 0.00
+ 0.300858000000 4.50
+ 0.302910980000 4.50
+ 0.302911000000 0.00
+ 0.302916980000 0.00
+ 0.302917000000 4.50
+ 0.304951480000 4.50
+ 0.304951500000 0.00
+ 0.304957480000 0.00
+ 0.304957500000 4.50
+ 0.306992480000 4.50
+ 0.306992500000 0.00
+ 0.306998480000 0.00
+ 0.306998500000 4.50
+ 0.309038980000 4.50
+ 0.309039000000 0.00
+ 0.309044980000 0.00
+ 0.309045000000 4.50
+ 0.311087980000 4.50
+ 0.311088000000 0.00
+ 0.311093980000 0.00
+ 0.311094000000 4.50
+ 0.313134980000 4.50
+ 0.313135000000 0.00
+ 0.313140980000 0.00
+ 0.313141000000 4.50
+ 0.315182480000 4.50
+ 0.315182500000 0.00
+ 0.315188480000 0.00
+ 0.315188500000 4.50
+ 0.317230480000 4.50
+ 0.317230500000 0.00
+ 0.317236480000 0.00
+ 0.317236500000 4.50
+ 0.319295980000 4.50
+ 0.319296000000 0.00
+ 0.319301980000 0.00
+ 0.319302000000 4.50
+ 0.321333480000 4.50
+ 0.321333500000 0.00
+ 0.321339480000 0.00
+ 0.321339500000 4.50
+ 0.323375980000 4.50
+ 0.323376000000 0.00
+ 0.323381980000 0.00
+ 0.323382000000 4.50
+ 0.325423480000 4.50
+ 0.325423500000 0.00
+ 0.325429480000 0.00
+ 0.325429500000 4.50
+ 0.327470980000 4.50
+ 0.327471000000 0.00
+ 0.327476980000 0.00
+ 0.327477000000 4.50
+ 0.329519980000 4.50
+ 0.329520000000 0.00
+ 0.329525980000 0.00
+ 0.329526000000 4.50
+ 0.331567480000 4.50
+ 0.331567500000 0.00
+ 0.331573480000 0.00
+ 0.331573500000 4.50
+ 0.333614980000 4.50
+ 0.333615000000 0.00
+ 0.333620980000 0.00
+ 0.333621000000 4.50
+ 0.335734980000 4.50
+ 0.335735000000 0.00
+ 0.335740980000 0.00
+ 0.335741000000 4.50
+ 0.337720480000 4.50
+ 0.337720500000 0.00
+ 0.337726480000 0.00
+ 0.337726500000 4.50
+ 0.339759480000 4.50
+ 0.339759500000 0.00
+ 0.339765480000 0.00
+ 0.339765500000 4.50
+ 0.341806480000 4.50
+ 0.341806500000 0.00
+ 0.341812480000 0.00
+ 0.341812500000 4.50
+ 0.343856980000 4.50
+ 0.343857000000 0.00
+ 0.343862980000 0.00
+ 0.343863000000 4.50
+ 0.345902980000 4.50
+ 0.345903000000 0.00
+ 0.345908980000 0.00
+ 0.345909000000 4.50
+ 0.347951980000 4.50
+ 0.347952000000 0.00
+ 0.347957980000 0.00
+ 0.347958000000 4.50
+ 0.349999980000 4.50
+ 0.350000000000 0.00
+ 0.350000020000 0.00
+ 0.370000000000 0.00
+ )
Vdriverow3 row3cmd 0 PWL(
+ 0.000000000000 4.50
+ 0.001840980000 4.50
+ 0.001841000000 0.00
+ 0.001846980000 0.00
+ 0.001847000000 4.50
+ 0.003888980000 4.50
+ 0.003889000000 0.00
+ 0.003894980000 0.00
+ 0.003895000000 4.50
+ 0.005934480000 4.50
+ 0.005934500000 0.00
+ 0.005940480000 0.00
+ 0.005940500000 4.50
+ 0.008054980000 4.50
+ 0.008055000000 0.00
+ 0.008060980000 0.00
+ 0.008061000000 4.50
+ 0.010041980000 4.50
+ 0.010042000000 0.00
+ 0.010047980000 0.00
+ 0.010048000000 4.50
+ 0.012078480000 4.50
+ 0.012078500000 0.00
+ 0.012084480000 0.00
+ 0.012084500000 4.50
+ 0.014126980000 4.50
+ 0.014127000000 0.00
+ 0.014132980000 0.00
+ 0.014133000000 4.50
+ 0.016175480000 4.50
+ 0.016175500000 0.00
+ 0.016181480000 0.00
+ 0.016181500000 4.50
+ 0.018227480000 4.50
+ 0.018227500000 0.00
+ 0.018233480000 0.00
+ 0.018233500000 4.50
+ 0.020271480000 4.50
+ 0.020271500000 0.00
+ 0.020277480000 0.00
+ 0.020277500000 4.50
+ 0.022318480000 4.50
+ 0.022318500000 0.00
+ 0.022324480000 0.00
+ 0.022324500000 4.50
+ 0.024383480000 4.50
+ 0.024383500000 0.00
+ 0.024389480000 0.00
+ 0.024389500000 4.50
+ 0.026425480000 4.50
+ 0.026425500000 0.00
+ 0.026431480000 0.00
+ 0.026431500000 4.50
+ 0.028462480000 4.50
+ 0.028462500000 0.00
+ 0.028468480000 0.00
+ 0.028468500000 4.50
+ 0.030511480000 4.50
+ 0.030511500000 0.00
+ 0.030517480000 0.00
+ 0.030517500000 4.50
+ 0.032559480000 4.50
+ 0.032559500000 0.00
+ 0.032565480000 0.00
+ 0.032565500000 4.50
+ 0.034610980000 4.50
+ 0.034611000000 0.00
+ 0.034616980000 0.00
+ 0.034617000000 4.50
+ 0.036654980000 4.50
+ 0.036655000000 0.00
+ 0.036660980000 0.00
+ 0.036661000000 4.50
+ 0.038703980000 4.50
+ 0.038704000000 0.00
+ 0.038709980000 0.00
+ 0.038710000000 4.50
+ 0.040766980000 4.50
+ 0.040767000000 0.00
+ 0.040772980000 0.00
+ 0.040773000000 4.50
+ 0.042812980000 4.50
+ 0.042813000000 0.00
+ 0.042818980000 0.00
+ 0.042819000000 4.50
+ 0.044846480000 4.50
+ 0.044846500000 0.00
+ 0.044852480000 0.00
+ 0.044852500000 4.50
+ 0.046895480000 4.50
+ 0.046895500000 0.00
+ 0.046901480000 0.00
+ 0.046901500000 4.50
+ 0.048943480000 4.50
+ 0.048943500000 0.00
+ 0.048949480000 0.00
+ 0.048949500000 4.50
+ 0.050995980000 4.50
+ 0.050996000000 0.00
+ 0.051001980000 0.00
+ 0.051002000000 4.50
+ 0.053039980000 4.50
+ 0.053040000000 0.00
+ 0.053045980000 0.00
+ 0.053046000000 4.50
+ 0.055088480000 4.50
+ 0.055088500000 0.00
+ 0.055094480000 0.00
+ 0.055094500000 4.50
+ 0.057151980000 4.50
+ 0.057152000000 0.00
+ 0.057157980000 0.00
+ 0.057158000000 4.50
+ 0.059196980000 4.50
+ 0.059197000000 0.00
+ 0.059202980000 0.00
+ 0.059203000000 4.50
+ 0.061233980000 4.50
+ 0.061234000000 0.00
+ 0.061239980000 0.00
+ 0.061240000000 4.50
+ 0.063279480000 4.50
+ 0.063279500000 0.00
+ 0.063285480000 0.00
+ 0.063285500000 4.50
+ 0.065326480000 4.50
+ 0.065326500000 0.00
+ 0.065332480000 0.00
+ 0.065332500000 4.50
+ 0.067375480000 4.50
+ 0.067375500000 0.00
+ 0.067381480000 0.00
+ 0.067381500000 4.50
+ 0.069422980000 4.50
+ 0.069423000000 0.00
+ 0.069428980000 0.00
+ 0.069429000000 4.50
+ 0.071471980000 4.50
+ 0.071472000000 0.00
+ 0.071477980000 0.00
+ 0.071478000000 4.50
+ 0.073590980000 4.50
+ 0.073591000000 0.00
+ 0.073596980000 0.00
+ 0.073597000000 4.50
+ 0.075573980000 4.50
+ 0.075574000000 0.00
+ 0.075579980000 0.00
+ 0.075580000000 4.50
+ 0.077614480000 4.50
+ 0.077614500000 0.00
+ 0.077620480000 0.00
+ 0.077620500000 4.50
+ 0.079663980000 4.50
+ 0.079664000000 0.00
+ 0.079669980000 0.00
+ 0.079670000000 4.50
+ 0.081710480000 4.50
+ 0.081710500000 0.00
+ 0.081716480000 0.00
+ 0.081716500000 4.50
+ 0.083759980000 4.50
+ 0.083760000000 0.00
+ 0.083765980000 0.00
+ 0.083766000000 4.50
+ 0.085806480000 4.50
+ 0.085806500000 0.00
+ 0.085812480000 0.00
+ 0.085812500000 4.50
+ 0.087854980000 4.50
+ 0.087855000000 0.00
+ 0.087860980000 0.00
+ 0.087861000000 4.50
+ 0.089919980000 4.50
+ 0.089920000000 0.00
+ 0.089925980000 0.00
+ 0.089926000000 4.50
+ 0.091956480000 4.50
+ 0.091956500000 0.00
+ 0.091962480000 0.00
+ 0.091962500000 4.50
+ 0.093998980000 4.50
+ 0.093999000000 0.00
+ 0.094004980000 0.00
+ 0.094005000000 4.50
+ 0.096051480000 4.50
+ 0.096051500000 0.00
+ 0.096057480000 0.00
+ 0.096057500000 4.50
+ 0.098096980000 4.50
+ 0.098097000000 0.00
+ 0.098102980000 0.00
+ 0.098103000000 4.50
+ 0.100143980000 4.50
+ 0.100144000000 0.00
+ 0.100149980000 0.00
+ 0.100150000000 4.50
+ 0.102190480000 4.50
+ 0.102190500000 0.00
+ 0.102196480000 0.00
+ 0.102196500000 4.50
+ 0.104240480000 4.50
+ 0.104240500000 0.00
+ 0.104246480000 0.00
+ 0.104246500000 4.50
+ 0.106304480000 4.50
+ 0.106304500000 0.00
+ 0.106310480000 0.00
+ 0.106310500000 4.50
+ 0.108343480000 4.50
+ 0.108343500000 0.00
+ 0.108349480000 0.00
+ 0.108349500000 4.50
+ 0.110383980000 4.50
+ 0.110384000000 0.00
+ 0.110389980000 0.00
+ 0.110390000000 4.50
+ 0.112430980000 4.50
+ 0.112431000000 0.00
+ 0.112436980000 0.00
+ 0.112437000000 4.50
+ 0.114479480000 4.50
+ 0.114479500000 0.00
+ 0.114485480000 0.00
+ 0.114485500000 4.50
+ 0.116526480000 4.50
+ 0.116526500000 0.00
+ 0.116532480000 0.00
+ 0.116532500000 4.50
+ 0.118574980000 4.50
+ 0.118575000000 0.00
+ 0.118580980000 0.00
+ 0.118581000000 4.50
+ 0.120623980000 4.50
+ 0.120624000000 0.00
+ 0.120629980000 0.00
+ 0.120630000000 4.50
+ 0.122686980000 4.50
+ 0.122687000000 0.00
+ 0.122692980000 0.00
+ 0.122693000000 4.50
+ 0.124724980000 4.50
+ 0.124725000000 0.00
+ 0.124730980000 0.00
+ 0.124731000000 4.50
+ 0.126771980000 4.50
+ 0.126772000000 0.00
+ 0.126777980000 0.00
+ 0.126778000000 4.50
+ 0.128815980000 4.50
+ 0.128816000000 0.00
+ 0.128821980000 0.00
+ 0.128822000000 4.50
+ 0.130863480000 4.50
+ 0.130863500000 0.00
+ 0.130869480000 0.00
+ 0.130869500000 4.50
+ 0.132911480000 4.50
+ 0.132911500000 0.00
+ 0.132917480000 0.00
+ 0.132917500000 4.50
+ 0.134963480000 4.50
+ 0.134963500000 0.00
+ 0.134969480000 0.00
+ 0.134969500000 4.50
+ 0.137006480000 4.50
+ 0.137006500000 0.00
+ 0.137012480000 0.00
+ 0.137012500000 4.50
+ 0.139126980000 4.50
+ 0.139127000000 0.00
+ 0.139132980000 0.00
+ 0.139133000000 4.50
+ 0.141109980000 4.50
+ 0.141110000000 0.00
+ 0.141115980000 0.00
+ 0.141116000000 4.50
+ 0.143155480000 4.50
+ 0.143155500000 0.00
+ 0.143161480000 0.00
+ 0.143161500000 4.50
+ 0.145198480000 4.50
+ 0.145198500000 0.00
+ 0.145204480000 0.00
+ 0.145204500000 4.50
+ 0.147247480000 4.50
+ 0.147247500000 0.00
+ 0.147253480000 0.00
+ 0.147253500000 4.50
+ 0.149294480000 4.50
+ 0.149294500000 0.00
+ 0.149300480000 0.00
+ 0.149300500000 4.50
+ 0.151349980000 4.50
+ 0.151350000000 0.00
+ 0.151355980000 0.00
+ 0.151356000000 4.50
+ 0.153392980000 4.50
+ 0.153393000000 0.00
+ 0.153398980000 0.00
+ 0.153399000000 4.50
+ 0.155455980000 4.50
+ 0.155456000000 0.00
+ 0.155461980000 0.00
+ 0.155462000000 4.50
+ 0.157492980000 4.50
+ 0.157493000000 0.00
+ 0.157498980000 0.00
+ 0.157499000000 4.50
+ 0.159539480000 4.50
+ 0.159539500000 0.00
+ 0.159545480000 0.00
+ 0.159545500000 4.50
+ 0.161582480000 4.50
+ 0.161582500000 0.00
+ 0.161588480000 0.00
+ 0.161588500000 4.50
+ 0.163630480000 4.50
+ 0.163630500000 0.00
+ 0.163636480000 0.00
+ 0.163636500000 4.50
+ 0.165682980000 4.50
+ 0.165683000000 0.00
+ 0.165688980000 0.00
+ 0.165689000000 4.50
+ 0.167731480000 4.50
+ 0.167731500000 0.00
+ 0.167737480000 0.00
+ 0.167737500000 4.50
+ 0.169775480000 4.50
+ 0.169775500000 0.00
+ 0.169781480000 0.00
+ 0.169781500000 4.50
+ 0.171839480000 4.50
+ 0.171839500000 0.00
+ 0.171845480000 0.00
+ 0.171845500000 4.50
+ 0.173878980000 4.50
+ 0.173879000000 0.00
+ 0.173884980000 0.00
+ 0.173885000000 4.50
+ 0.175923980000 4.50
+ 0.175924000000 0.00
+ 0.175929980000 0.00
+ 0.175930000000 4.50
+ 0.177970980000 4.50
+ 0.177971000000 0.00
+ 0.177976980000 0.00
+ 0.177977000000 4.50
+ 0.180014480000 4.50
+ 0.180014500000 0.00
+ 0.180020480000 0.00
+ 0.180020500000 4.50
+ 0.182063480000 4.50
+ 0.182063500000 0.00
+ 0.182069480000 0.00
+ 0.182069500000 4.50
+ 0.184114980000 4.50
+ 0.184115000000 0.00
+ 0.184120980000 0.00
+ 0.184121000000 4.50
+ 0.186158980000 4.50
+ 0.186159000000 0.00
+ 0.186164980000 0.00
+ 0.186165000000 4.50
+ 0.188223480000 4.50
+ 0.188223500000 0.00
+ 0.188229480000 0.00
+ 0.188229500000 4.50
+ 0.190260480000 4.50
+ 0.190260500000 0.00
+ 0.190266480000 0.00
+ 0.190266500000 4.50
+ 0.192306480000 4.50
+ 0.192306500000 0.00
+ 0.192312480000 0.00
+ 0.192312500000 4.50
+ 0.194350980000 4.50
+ 0.194351000000 0.00
+ 0.194356980000 0.00
+ 0.194357000000 4.50
+ 0.196398980000 4.50
+ 0.196399000000 0.00
+ 0.196404980000 0.00
+ 0.196405000000 4.50
+ 0.198446480000 4.50
+ 0.198446500000 0.00
+ 0.198452480000 0.00
+ 0.198452500000 4.50
+ 0.200494480000 4.50
+ 0.200494500000 0.00
+ 0.200500480000 0.00
+ 0.200500500000 4.50
+ 0.202543480000 4.50
+ 0.202543500000 0.00
+ 0.202549480000 0.00
+ 0.202549500000 4.50
+ 0.204663480000 4.50
+ 0.204663500000 0.00
+ 0.204669480000 0.00
+ 0.204669500000 4.50
+ 0.206644980000 4.50
+ 0.206645000000 0.00
+ 0.206650980000 0.00
+ 0.206651000000 4.50
+ 0.208686480000 4.50
+ 0.208686500000 0.00
+ 0.208692480000 0.00
+ 0.208692500000 4.50
+ 0.210735480000 4.50
+ 0.210735500000 0.00
+ 0.210741480000 0.00
+ 0.210741500000 4.50
+ 0.212782980000 4.50
+ 0.212783000000 0.00
+ 0.212788980000 0.00
+ 0.212789000000 4.50
+ 0.214830980000 4.50
+ 0.214831000000 0.00
+ 0.214836980000 0.00
+ 0.214837000000 4.50
+ 0.216878480000 4.50
+ 0.216878500000 0.00
+ 0.216884480000 0.00
+ 0.216884500000 4.50
+ 0.218927980000 4.50
+ 0.218928000000 0.00
+ 0.218933980000 0.00
+ 0.218934000000 4.50
+ 0.220992480000 4.50
+ 0.220992500000 0.00
+ 0.220998480000 0.00
+ 0.220998500000 4.50
+ 0.223028480000 4.50
+ 0.223028500000 0.00
+ 0.223034480000 0.00
+ 0.223034500000 4.50
+ 0.225070480000 4.50
+ 0.225070500000 0.00
+ 0.225076480000 0.00
+ 0.225076500000 4.50
+ 0.227118980000 4.50
+ 0.227119000000 0.00
+ 0.227124980000 0.00
+ 0.227125000000 4.50
+ 0.229166980000 4.50
+ 0.229167000000 0.00
+ 0.229172980000 0.00
+ 0.229173000000 4.50
+ 0.231214480000 4.50
+ 0.231214500000 0.00
+ 0.231220480000 0.00
+ 0.231220500000 4.50
+ 0.233263980000 4.50
+ 0.233264000000 0.00
+ 0.233269980000 0.00
+ 0.233270000000 4.50
+ 0.235310480000 4.50
+ 0.235310500000 0.00
+ 0.235316480000 0.00
+ 0.235316500000 4.50
+ 0.237374980000 4.50
+ 0.237375000000 0.00
+ 0.237380980000 0.00
+ 0.237381000000 4.50
+ 0.239413480000 4.50
+ 0.239413500000 0.00
+ 0.239419480000 0.00
+ 0.239419500000 4.50
+ 0.241454480000 4.50
+ 0.241454500000 0.00
+ 0.241460480000 0.00
+ 0.241460500000 4.50
+ 0.243503980000 4.50
+ 0.243504000000 0.00
+ 0.243509980000 0.00
+ 0.243510000000 4.50
+ 0.245550980000 4.50
+ 0.245551000000 0.00
+ 0.245556980000 0.00
+ 0.245557000000 4.50
+ 0.247599480000 4.50
+ 0.247599500000 0.00
+ 0.247605480000 0.00
+ 0.247605500000 4.50
+ 0.249646480000 4.50
+ 0.249646500000 0.00
+ 0.249652480000 0.00
+ 0.249652500000 4.50
+ 0.251701480000 4.50
+ 0.251701500000 0.00
+ 0.251707480000 0.00
+ 0.251707500000 4.50
+ 0.253761980000 4.50
+ 0.253762000000 0.00
+ 0.253767980000 0.00
+ 0.253768000000 4.50
+ 0.255796480000 4.50
+ 0.255796500000 0.00
+ 0.255802480000 0.00
+ 0.255802500000 4.50
+ 0.257838980000 4.50
+ 0.257839000000 0.00
+ 0.257844980000 0.00
+ 0.257845000000 4.50
+ 0.259891480000 4.50
+ 0.259891500000 0.00
+ 0.259897480000 0.00
+ 0.259897500000 4.50
+ 0.261935980000 4.50
+ 0.261936000000 0.00
+ 0.261941980000 0.00
+ 0.261942000000 4.50
+ 0.263982480000 4.50
+ 0.263982500000 0.00
+ 0.263988480000 0.00
+ 0.263988500000 4.50
+ 0.266031480000 4.50
+ 0.266031500000 0.00
+ 0.266037480000 0.00
+ 0.266037500000 4.50
+ 0.268083480000 4.50
+ 0.268083500000 0.00
+ 0.268089480000 0.00
+ 0.268089500000 4.50
+ 0.270198980000 4.50
+ 0.270199000000 0.00
+ 0.270204980000 0.00
+ 0.270205000000 4.50
+ 0.272181980000 4.50
+ 0.272182000000 0.00
+ 0.272187980000 0.00
+ 0.272188000000 4.50
+ 0.274222980000 4.50
+ 0.274223000000 0.00
+ 0.274228980000 0.00
+ 0.274229000000 4.50
+ 0.276275980000 4.50
+ 0.276276000000 0.00
+ 0.276281980000 0.00
+ 0.276282000000 4.50
+ 0.278321480000 4.50
+ 0.278321500000 0.00
+ 0.278327480000 0.00
+ 0.278327500000 4.50
+ 0.280367480000 4.50
+ 0.280367500000 0.00
+ 0.280373480000 0.00
+ 0.280373500000 4.50
+ 0.282415980000 4.50
+ 0.282416000000 0.00
+ 0.282421980000 0.00
+ 0.282422000000 4.50
+ 0.284468480000 4.50
+ 0.284468500000 0.00
+ 0.284474480000 0.00
+ 0.284474500000 4.50
+ 0.286527980000 4.50
+ 0.286528000000 0.00
+ 0.286533980000 0.00
+ 0.286534000000 4.50
+ 0.288564980000 4.50
+ 0.288565000000 0.00
+ 0.288570980000 0.00
+ 0.288571000000 4.50
+ 0.290607980000 4.50
+ 0.290608000000 0.00
+ 0.290613980000 0.00
+ 0.290614000000 4.50
+ 0.292659480000 4.50
+ 0.292659500000 0.00
+ 0.292665480000 0.00
+ 0.292665500000 4.50
+ 0.294702980000 4.50
+ 0.294703000000 0.00
+ 0.294708980000 0.00
+ 0.294709000000 4.50
+ 0.296752980000 4.50
+ 0.296753000000 0.00
+ 0.296758980000 0.00
+ 0.296759000000 4.50
+ 0.298798980000 4.50
+ 0.298799000000 0.00
+ 0.298804980000 0.00
+ 0.298805000000 4.50
+ 0.300851980000 4.50
+ 0.300852000000 0.00
+ 0.300857980000 0.00
+ 0.300858000000 4.50
+ 0.302910980000 4.50
+ 0.302911000000 0.00
+ 0.302916980000 0.00
+ 0.302917000000 4.50
+ 0.304951480000 4.50
+ 0.304951500000 0.00
+ 0.304957480000 0.00
+ 0.304957500000 4.50
+ 0.306992480000 4.50
+ 0.306992500000 0.00
+ 0.306998480000 0.00
+ 0.306998500000 4.50
+ 0.309038980000 4.50
+ 0.309039000000 0.00
+ 0.309044980000 0.00
+ 0.309045000000 4.50
+ 0.311087980000 4.50
+ 0.311088000000 0.00
+ 0.311093980000 0.00
+ 0.311094000000 4.50
+ 0.313134980000 4.50
+ 0.313135000000 0.00
+ 0.313140980000 0.00
+ 0.313141000000 4.50
+ 0.315182480000 4.50
+ 0.315182500000 0.00
+ 0.315188480000 0.00
+ 0.315188500000 4.50
+ 0.317230480000 4.50
+ 0.317230500000 0.00
+ 0.317236480000 0.00
+ 0.317236500000 4.50
+ 0.319295980000 4.50
+ 0.319296000000 0.00
+ 0.319301980000 0.00
+ 0.319302000000 4.50
+ 0.321333480000 4.50
+ 0.321333500000 0.00
+ 0.321339480000 0.00
+ 0.321339500000 4.50
+ 0.323375980000 4.50
+ 0.323376000000 0.00
+ 0.323381980000 0.00
+ 0.323382000000 4.50
+ 0.325423480000 4.50
+ 0.325423500000 0.00
+ 0.325429480000 0.00
+ 0.325429500000 4.50
+ 0.327470980000 4.50
+ 0.327471000000 0.00
+ 0.327476980000 0.00
+ 0.327477000000 4.50
+ 0.329519980000 4.50
+ 0.329520000000 0.00
+ 0.329525980000 0.00
+ 0.329526000000 4.50
+ 0.331567480000 4.50
+ 0.331567500000 0.00
+ 0.331573480000 0.00
+ 0.331573500000 4.50
+ 0.333614980000 4.50
+ 0.333615000000 0.00
+ 0.333620980000 0.00
+ 0.333621000000 4.50
+ 0.335734980000 4.50
+ 0.335735000000 0.00
+ 0.335740980000 0.00
+ 0.335741000000 4.50
+ 0.337720480000 4.50
+ 0.337720500000 0.00
+ 0.337726480000 0.00
+ 0.337726500000 4.50
+ 0.339759480000 4.50
+ 0.339759500000 0.00
+ 0.339765480000 0.00
+ 0.339765500000 4.50
+ 0.341806480000 4.50
+ 0.341806500000 0.00
+ 0.341812480000 0.00
+ 0.341812500000 4.50
+ 0.343856980000 4.50
+ 0.343857000000 0.00
+ 0.343862980000 0.00
+ 0.343863000000 4.50
+ 0.345902980000 4.50
+ 0.345903000000 0.00
+ 0.345908980000 0.00
+ 0.345909000000 4.50
+ 0.347951980000 4.50
+ 0.347952000000 0.00
+ 0.347957980000 0.00
+ 0.347958000000 4.50
+ 0.349999980000 4.50
+ 0.350000000000 0.00
+ 0.350000020000 0.00
+ 0.370000000000 0.00
+ )
Vdriverow4 row4cmd 0 PWL(
+ 0.000000000000 4.50
+ 0.001840980000 4.50
+ 0.001841000000 0.00
+ 0.001846980000 0.00
+ 0.001847000000 4.50
+ 0.003888980000 4.50
+ 0.003889000000 0.00
+ 0.003894980000 0.00
+ 0.003895000000 4.50
+ 0.005934480000 4.50
+ 0.005934500000 0.00
+ 0.005940480000 0.00
+ 0.005940500000 4.50
+ 0.008054980000 4.50
+ 0.008055000000 0.00
+ 0.008060980000 0.00
+ 0.008061000000 4.50
+ 0.010041980000 4.50
+ 0.010042000000 0.00
+ 0.010047980000 0.00
+ 0.010048000000 4.50
+ 0.012078480000 4.50
+ 0.012078500000 0.00
+ 0.012084480000 0.00
+ 0.012084500000 4.50
+ 0.014126980000 4.50
+ 0.014127000000 0.00
+ 0.014132980000 0.00
+ 0.014133000000 4.50
+ 0.016175480000 4.50
+ 0.016175500000 0.00
+ 0.016181480000 0.00
+ 0.016181500000 4.50
+ 0.018227480000 4.50
+ 0.018227500000 0.00
+ 0.018233480000 0.00
+ 0.018233500000 4.50
+ 0.020271480000 4.50
+ 0.020271500000 0.00
+ 0.020277480000 0.00
+ 0.020277500000 4.50
+ 0.022318480000 4.50
+ 0.022318500000 0.00
+ 0.022324480000 0.00
+ 0.022324500000 4.50
+ 0.024383480000 4.50
+ 0.024383500000 0.00
+ 0.024389480000 0.00
+ 0.024389500000 4.50
+ 0.026425480000 4.50
+ 0.026425500000 0.00
+ 0.026431480000 0.00
+ 0.026431500000 4.50
+ 0.028462480000 4.50
+ 0.028462500000 0.00
+ 0.028468480000 0.00
+ 0.028468500000 4.50
+ 0.030511480000 4.50
+ 0.030511500000 0.00
+ 0.030517480000 0.00
+ 0.030517500000 4.50
+ 0.032559480000 4.50
+ 0.032559500000 0.00
+ 0.032565480000 0.00
+ 0.032565500000 4.50
+ 0.034610980000 4.50
+ 0.034611000000 0.00
+ 0.034616980000 0.00
+ 0.034617000000 4.50
+ 0.036654980000 4.50
+ 0.036655000000 0.00
+ 0.036660980000 0.00
+ 0.036661000000 4.50
+ 0.038703980000 4.50
+ 0.038704000000 0.00
+ 0.038709980000 0.00
+ 0.038710000000 4.50
+ 0.040766980000 4.50
+ 0.040767000000 0.00
+ 0.040772980000 0.00
+ 0.040773000000 4.50
+ 0.042812980000 4.50
+ 0.042813000000 0.00
+ 0.042818980000 0.00
+ 0.042819000000 4.50
+ 0.044846480000 4.50
+ 0.044846500000 0.00
+ 0.044852480000 0.00
+ 0.044852500000 4.50
+ 0.046895480000 4.50
+ 0.046895500000 0.00
+ 0.046901480000 0.00
+ 0.046901500000 4.50
+ 0.048943480000 4.50
+ 0.048943500000 0.00
+ 0.048949480000 0.00
+ 0.048949500000 4.50
+ 0.050995980000 4.50
+ 0.050996000000 0.00
+ 0.051001980000 0.00
+ 0.051002000000 4.50
+ 0.053039980000 4.50
+ 0.053040000000 0.00
+ 0.053045980000 0.00
+ 0.053046000000 4.50
+ 0.055088480000 4.50
+ 0.055088500000 0.00
+ 0.055094480000 0.00
+ 0.055094500000 4.50
+ 0.057151980000 4.50
+ 0.057152000000 0.00
+ 0.057157980000 0.00
+ 0.057158000000 4.50
+ 0.059196980000 4.50
+ 0.059197000000 0.00
+ 0.059202980000 0.00
+ 0.059203000000 4.50
+ 0.061233980000 4.50
+ 0.061234000000 0.00
+ 0.061239980000 0.00
+ 0.061240000000 4.50
+ 0.063279480000 4.50
+ 0.063279500000 0.00
+ 0.063285480000 0.00
+ 0.063285500000 4.50
+ 0.065326480000 4.50
+ 0.065326500000 0.00
+ 0.065332480000 0.00
+ 0.065332500000 4.50
+ 0.067375480000 4.50
+ 0.067375500000 0.00
+ 0.067381480000 0.00
+ 0.067381500000 4.50
+ 0.069422980000 4.50
+ 0.069423000000 0.00
+ 0.069428980000 0.00
+ 0.069429000000 4.50
+ 0.071471980000 4.50
+ 0.071472000000 0.00
+ 0.071477980000 0.00
+ 0.071478000000 4.50
+ 0.073590980000 4.50
+ 0.073591000000 0.00
+ 0.073596980000 0.00
+ 0.073597000000 4.50
+ 0.075573980000 4.50
+ 0.075574000000 0.00
+ 0.075579980000 0.00
+ 0.075580000000 4.50
+ 0.077614480000 4.50
+ 0.077614500000 0.00
+ 0.077620480000 0.00
+ 0.077620500000 4.50
+ 0.079663980000 4.50
+ 0.079664000000 0.00
+ 0.079669980000 0.00
+ 0.079670000000 4.50
+ 0.081710480000 4.50
+ 0.081710500000 0.00
+ 0.081716480000 0.00
+ 0.081716500000 4.50
+ 0.083759980000 4.50
+ 0.083760000000 0.00
+ 0.083765980000 0.00
+ 0.083766000000 4.50
+ 0.085806480000 4.50
+ 0.085806500000 0.00
+ 0.085812480000 0.00
+ 0.085812500000 4.50
+ 0.087854980000 4.50
+ 0.087855000000 0.00
+ 0.087860980000 0.00
+ 0.087861000000 4.50
+ 0.089919980000 4.50
+ 0.089920000000 0.00
+ 0.089925980000 0.00
+ 0.089926000000 4.50
+ 0.091956480000 4.50
+ 0.091956500000 0.00
+ 0.091962480000 0.00
+ 0.091962500000 4.50
+ 0.093998980000 4.50
+ 0.093999000000 0.00
+ 0.094004980000 0.00
+ 0.094005000000 4.50
+ 0.096051480000 4.50
+ 0.096051500000 0.00
+ 0.096057480000 0.00
+ 0.096057500000 4.50
+ 0.098096980000 4.50
+ 0.098097000000 0.00
+ 0.098102980000 0.00
+ 0.098103000000 4.50
+ 0.100143980000 4.50
+ 0.100144000000 0.00
+ 0.100149980000 0.00
+ 0.100150000000 4.50
+ 0.102190480000 4.50
+ 0.102190500000 0.00
+ 0.102196480000 0.00
+ 0.102196500000 4.50
+ 0.104240480000 4.50
+ 0.104240500000 0.00
+ 0.104246480000 0.00
+ 0.104246500000 4.50
+ 0.106304480000 4.50
+ 0.106304500000 0.00
+ 0.106310480000 0.00
+ 0.106310500000 4.50
+ 0.108343480000 4.50
+ 0.108343500000 0.00
+ 0.108349480000 0.00
+ 0.108349500000 4.50
+ 0.110383980000 4.50
+ 0.110384000000 0.00
+ 0.110389980000 0.00
+ 0.110390000000 4.50
+ 0.112430980000 4.50
+ 0.112431000000 0.00
+ 0.112436980000 0.00
+ 0.112437000000 4.50
+ 0.114479480000 4.50
+ 0.114479500000 0.00
+ 0.114485480000 0.00
+ 0.114485500000 4.50
+ 0.116526480000 4.50
+ 0.116526500000 0.00
+ 0.116532480000 0.00
+ 0.116532500000 4.50
+ 0.118574980000 4.50
+ 0.118575000000 0.00
+ 0.118580980000 0.00
+ 0.118581000000 4.50
+ 0.120623980000 4.50
+ 0.120624000000 0.00
+ 0.120629980000 0.00
+ 0.120630000000 4.50
+ 0.122686980000 4.50
+ 0.122687000000 0.00
+ 0.122692980000 0.00
+ 0.122693000000 4.50
+ 0.124724980000 4.50
+ 0.124725000000 0.00
+ 0.124730980000 0.00
+ 0.124731000000 4.50
+ 0.126771980000 4.50
+ 0.126772000000 0.00
+ 0.126777980000 0.00
+ 0.126778000000 4.50
+ 0.128815980000 4.50
+ 0.128816000000 0.00
+ 0.128821980000 0.00
+ 0.128822000000 4.50
+ 0.130863480000 4.50
+ 0.130863500000 0.00
+ 0.130869480000 0.00
+ 0.130869500000 4.50
+ 0.132911480000 4.50
+ 0.132911500000 0.00
+ 0.132917480000 0.00
+ 0.132917500000 4.50
+ 0.134963480000 4.50
+ 0.134963500000 0.00
+ 0.134969480000 0.00
+ 0.134969500000 4.50
+ 0.137006480000 4.50
+ 0.137006500000 0.00
+ 0.137012480000 0.00
+ 0.137012500000 4.50
+ 0.139126980000 4.50
+ 0.139127000000 0.00
+ 0.139132980000 0.00
+ 0.139133000000 4.50
+ 0.141109980000 4.50
+ 0.141110000000 0.00
+ 0.141115980000 0.00
+ 0.141116000000 4.50
+ 0.143155480000 4.50
+ 0.143155500000 0.00
+ 0.143161480000 0.00
+ 0.143161500000 4.50
+ 0.145198480000 4.50
+ 0.145198500000 0.00
+ 0.145204480000 0.00
+ 0.145204500000 4.50
+ 0.147247480000 4.50
+ 0.147247500000 0.00
+ 0.147253480000 0.00
+ 0.147253500000 4.50
+ 0.149294480000 4.50
+ 0.149294500000 0.00
+ 0.149300480000 0.00
+ 0.149300500000 4.50
+ 0.151349980000 4.50
+ 0.151350000000 0.00
+ 0.151355980000 0.00
+ 0.151356000000 4.50
+ 0.153392980000 4.50
+ 0.153393000000 0.00
+ 0.153398980000 0.00
+ 0.153399000000 4.50
+ 0.155455980000 4.50
+ 0.155456000000 0.00
+ 0.155461980000 0.00
+ 0.155462000000 4.50
+ 0.157492980000 4.50
+ 0.157493000000 0.00
+ 0.157498980000 0.00
+ 0.157499000000 4.50
+ 0.159539480000 4.50
+ 0.159539500000 0.00
+ 0.159545480000 0.00
+ 0.159545500000 4.50
+ 0.161582480000 4.50
+ 0.161582500000 0.00
+ 0.161588480000 0.00
+ 0.161588500000 4.50
+ 0.163630480000 4.50
+ 0.163630500000 0.00
+ 0.163636480000 0.00
+ 0.163636500000 4.50
+ 0.165682980000 4.50
+ 0.165683000000 0.00
+ 0.165688980000 0.00
+ 0.165689000000 4.50
+ 0.167731480000 4.50
+ 0.167731500000 0.00
+ 0.167737480000 0.00
+ 0.167737500000 4.50
+ 0.169775480000 4.50
+ 0.169775500000 0.00
+ 0.169781480000 0.00
+ 0.169781500000 4.50
+ 0.171839480000 4.50
+ 0.171839500000 0.00
+ 0.171845480000 0.00
+ 0.171845500000 4.50
+ 0.173878980000 4.50
+ 0.173879000000 0.00
+ 0.173884980000 0.00
+ 0.173885000000 4.50
+ 0.175923980000 4.50
+ 0.175924000000 0.00
+ 0.175929980000 0.00
+ 0.175930000000 4.50
+ 0.177970980000 4.50
+ 0.177971000000 0.00
+ 0.177976980000 0.00
+ 0.177977000000 4.50
+ 0.180014480000 4.50
+ 0.180014500000 0.00
+ 0.180020480000 0.00
+ 0.180020500000 4.50
+ 0.182063480000 4.50
+ 0.182063500000 0.00
+ 0.182069480000 0.00
+ 0.182069500000 4.50
+ 0.184114980000 4.50
+ 0.184115000000 0.00
+ 0.184120980000 0.00
+ 0.184121000000 4.50
+ 0.186158980000 4.50
+ 0.186159000000 0.00
+ 0.186164980000 0.00
+ 0.186165000000 4.50
+ 0.188223480000 4.50
+ 0.188223500000 0.00
+ 0.188229480000 0.00
+ 0.188229500000 4.50
+ 0.190260480000 4.50
+ 0.190260500000 0.00
+ 0.190266480000 0.00
+ 0.190266500000 4.50
+ 0.192306480000 4.50
+ 0.192306500000 0.00
+ 0.192312480000 0.00
+ 0.192312500000 4.50
+ 0.194350980000 4.50
+ 0.194351000000 0.00
+ 0.194356980000 0.00
+ 0.194357000000 4.50
+ 0.196398980000 4.50
+ 0.196399000000 0.00
+ 0.196404980000 0.00
+ 0.196405000000 4.50
+ 0.198446480000 4.50
+ 0.198446500000 0.00
+ 0.198452480000 0.00
+ 0.198452500000 4.50
+ 0.200494480000 4.50
+ 0.200494500000 0.00
+ 0.200500480000 0.00
+ 0.200500500000 4.50
+ 0.202543480000 4.50
+ 0.202543500000 0.00
+ 0.202549480000 0.00
+ 0.202549500000 4.50
+ 0.204663480000 4.50
+ 0.204663500000 0.00
+ 0.204669480000 0.00
+ 0.204669500000 4.50
+ 0.206644980000 4.50
+ 0.206645000000 0.00
+ 0.206650980000 0.00
+ 0.206651000000 4.50
+ 0.208686480000 4.50
+ 0.208686500000 0.00
+ 0.208692480000 0.00
+ 0.208692500000 4.50
+ 0.210735480000 4.50
+ 0.210735500000 0.00
+ 0.210741480000 0.00
+ 0.210741500000 4.50
+ 0.212782980000 4.50
+ 0.212783000000 0.00
+ 0.212788980000 0.00
+ 0.212789000000 4.50
+ 0.214830980000 4.50
+ 0.214831000000 0.00
+ 0.214836980000 0.00
+ 0.214837000000 4.50
+ 0.216878480000 4.50
+ 0.216878500000 0.00
+ 0.216884480000 0.00
+ 0.216884500000 4.50
+ 0.218927980000 4.50
+ 0.218928000000 0.00
+ 0.218933980000 0.00
+ 0.218934000000 4.50
+ 0.220992480000 4.50
+ 0.220992500000 0.00
+ 0.220998480000 0.00
+ 0.220998500000 4.50
+ 0.223028480000 4.50
+ 0.223028500000 0.00
+ 0.223034480000 0.00
+ 0.223034500000 4.50
+ 0.225070480000 4.50
+ 0.225070500000 0.00
+ 0.225076480000 0.00
+ 0.225076500000 4.50
+ 0.227118980000 4.50
+ 0.227119000000 0.00
+ 0.227124980000 0.00
+ 0.227125000000 4.50
+ 0.229166980000 4.50
+ 0.229167000000 0.00
+ 0.229172980000 0.00
+ 0.229173000000 4.50
+ 0.231214480000 4.50
+ 0.231214500000 0.00
+ 0.231220480000 0.00
+ 0.231220500000 4.50
+ 0.233263980000 4.50
+ 0.233264000000 0.00
+ 0.233269980000 0.00
+ 0.233270000000 4.50
+ 0.235310480000 4.50
+ 0.235310500000 0.00
+ 0.235316480000 0.00
+ 0.235316500000 4.50
+ 0.237374980000 4.50
+ 0.237375000000 0.00
+ 0.237380980000 0.00
+ 0.237381000000 4.50
+ 0.239413480000 4.50
+ 0.239413500000 0.00
+ 0.239419480000 0.00
+ 0.239419500000 4.50
+ 0.241454480000 4.50
+ 0.241454500000 0.00
+ 0.241460480000 0.00
+ 0.241460500000 4.50
+ 0.243503980000 4.50
+ 0.243504000000 0.00
+ 0.243509980000 0.00
+ 0.243510000000 4.50
+ 0.245550980000 4.50
+ 0.245551000000 0.00
+ 0.245556980000 0.00
+ 0.245557000000 4.50
+ 0.247599480000 4.50
+ 0.247599500000 0.00
+ 0.247605480000 0.00
+ 0.247605500000 4.50
+ 0.249646480000 4.50
+ 0.249646500000 0.00
+ 0.249652480000 0.00
+ 0.249652500000 4.50
+ 0.251701480000 4.50
+ 0.251701500000 0.00
+ 0.251707480000 0.00
+ 0.251707500000 4.50
+ 0.253761980000 4.50
+ 0.253762000000 0.00
+ 0.253767980000 0.00
+ 0.253768000000 4.50
+ 0.255796480000 4.50
+ 0.255796500000 0.00
+ 0.255802480000 0.00
+ 0.255802500000 4.50
+ 0.257838980000 4.50
+ 0.257839000000 0.00
+ 0.257844980000 0.00
+ 0.257845000000 4.50
+ 0.259891480000 4.50
+ 0.259891500000 0.00
+ 0.259897480000 0.00
+ 0.259897500000 4.50
+ 0.261935980000 4.50
+ 0.261936000000 0.00
+ 0.261941980000 0.00
+ 0.261942000000 4.50
+ 0.263982480000 4.50
+ 0.263982500000 0.00
+ 0.263988480000 0.00
+ 0.263988500000 4.50
+ 0.266031480000 4.50
+ 0.266031500000 0.00
+ 0.266037480000 0.00
+ 0.266037500000 4.50
+ 0.268083480000 4.50
+ 0.268083500000 0.00
+ 0.268089480000 0.00
+ 0.268089500000 4.50
+ 0.270198980000 4.50
+ 0.270199000000 0.00
+ 0.270204980000 0.00
+ 0.270205000000 4.50
+ 0.272181980000 4.50
+ 0.272182000000 0.00
+ 0.272187980000 0.00
+ 0.272188000000 4.50
+ 0.274222980000 4.50
+ 0.274223000000 0.00
+ 0.274228980000 0.00
+ 0.274229000000 4.50
+ 0.276275980000 4.50
+ 0.276276000000 0.00
+ 0.276281980000 0.00
+ 0.276282000000 4.50
+ 0.278321480000 4.50
+ 0.278321500000 0.00
+ 0.278327480000 0.00
+ 0.278327500000 4.50
+ 0.280367480000 4.50
+ 0.280367500000 0.00
+ 0.280373480000 0.00
+ 0.280373500000 4.50
+ 0.282415980000 4.50
+ 0.282416000000 0.00
+ 0.282421980000 0.00
+ 0.282422000000 4.50
+ 0.284468480000 4.50
+ 0.284468500000 0.00
+ 0.284474480000 0.00
+ 0.284474500000 4.50
+ 0.286527980000 4.50
+ 0.286528000000 0.00
+ 0.286533980000 0.00
+ 0.286534000000 4.50
+ 0.288564980000 4.50
+ 0.288565000000 0.00
+ 0.288570980000 0.00
+ 0.288571000000 4.50
+ 0.290607980000 4.50
+ 0.290608000000 0.00
+ 0.290613980000 0.00
+ 0.290614000000 4.50
+ 0.292659480000 4.50
+ 0.292659500000 0.00
+ 0.292665480000 0.00
+ 0.292665500000 4.50
+ 0.294702980000 4.50
+ 0.294703000000 0.00
+ 0.294708980000 0.00
+ 0.294709000000 4.50
+ 0.296752980000 4.50
+ 0.296753000000 0.00
+ 0.296758980000 0.00
+ 0.296759000000 4.50
+ 0.298798980000 4.50
+ 0.298799000000 0.00
+ 0.298804980000 0.00
+ 0.298805000000 4.50
+ 0.300851980000 4.50
+ 0.300852000000 0.00
+ 0.300857980000 0.00
+ 0.300858000000 4.50
+ 0.302910980000 4.50
+ 0.302911000000 0.00
+ 0.302916980000 0.00
+ 0.302917000000 4.50
+ 0.304951480000 4.50
+ 0.304951500000 0.00
+ 0.304957480000 0.00
+ 0.304957500000 4.50
+ 0.306992480000 4.50
+ 0.306992500000 0.00
+ 0.306998480000 0.00
+ 0.306998500000 4.50
+ 0.309038980000 4.50
+ 0.309039000000 0.00
+ 0.309044980000 0.00
+ 0.309045000000 4.50
+ 0.311087980000 4.50
+ 0.311088000000 0.00
+ 0.311093980000 0.00
+ 0.311094000000 4.50
+ 0.313134980000 4.50
+ 0.313135000000 0.00
+ 0.313140980000 0.00
+ 0.313141000000 4.50
+ 0.315182480000 4.50
+ 0.315182500000 0.00
+ 0.315188480000 0.00
+ 0.315188500000 4.50
+ 0.317230480000 4.50
+ 0.317230500000 0.00
+ 0.317236480000 0.00
+ 0.317236500000 4.50
+ 0.319295980000 4.50
+ 0.319296000000 0.00
+ 0.319301980000 0.00
+ 0.319302000000 4.50
+ 0.321333480000 4.50
+ 0.321333500000 0.00
+ 0.321339480000 0.00
+ 0.321339500000 4.50
+ 0.323375980000 4.50
+ 0.323376000000 0.00
+ 0.323381980000 0.00
+ 0.323382000000 4.50
+ 0.325423480000 4.50
+ 0.325423500000 0.00
+ 0.325429480000 0.00
+ 0.325429500000 4.50
+ 0.327470980000 4.50
+ 0.327471000000 0.00
+ 0.327476980000 0.00
+ 0.327477000000 4.50
+ 0.329519980000 4.50
+ 0.329520000000 0.00
+ 0.329525980000 0.00
+ 0.329526000000 4.50
+ 0.331567480000 4.50
+ 0.331567500000 0.00
+ 0.331573480000 0.00
+ 0.331573500000 4.50
+ 0.333614980000 4.50
+ 0.333615000000 0.00
+ 0.333620980000 0.00
+ 0.333621000000 4.50
+ 0.335734980000 4.50
+ 0.335735000000 0.00
+ 0.335740980000 0.00
+ 0.335741000000 4.50
+ 0.337720480000 4.50
+ 0.337720500000 0.00
+ 0.337726480000 0.00
+ 0.337726500000 4.50
+ 0.339759480000 4.50
+ 0.339759500000 0.00
+ 0.339765480000 0.00
+ 0.339765500000 4.50
+ 0.341806480000 4.50
+ 0.341806500000 0.00
+ 0.341812480000 0.00
+ 0.341812500000 4.50
+ 0.343856980000 4.50
+ 0.343857000000 0.00
+ 0.343862980000 0.00
+ 0.343863000000 4.50
+ 0.345902980000 4.50
+ 0.345903000000 0.00
+ 0.345908980000 0.00
+ 0.345909000000 4.50
+ 0.347951980000 4.50
+ 0.347952000000 0.00
+ 0.347957980000 0.00
+ 0.347958000000 4.50
+ 0.349999980000 4.50
+ 0.350000000000 0.00
+ 0.350000020000 0.00
+ 0.370000000000 0.00
+ )
Vdriverow5 row5cmd 0 PWL(
+ 0.000000000000 4.50
+ 0.001840980000 4.50
+ 0.001841000000 0.00
+ 0.001846980000 0.00
+ 0.001847000000 4.50
+ 0.003888980000 4.50
+ 0.003889000000 0.00
+ 0.003894980000 0.00
+ 0.003895000000 4.50
+ 0.005934480000 4.50
+ 0.005934500000 0.00
+ 0.005940480000 0.00
+ 0.005940500000 4.50
+ 0.008054980000 4.50
+ 0.008055000000 0.00
+ 0.008060980000 0.00
+ 0.008061000000 4.50
+ 0.010041980000 4.50
+ 0.010042000000 0.00
+ 0.010047980000 0.00
+ 0.010048000000 4.50
+ 0.012078480000 4.50
+ 0.012078500000 0.00
+ 0.012084480000 0.00
+ 0.012084500000 4.50
+ 0.014126980000 4.50
+ 0.014127000000 0.00
+ 0.014132980000 0.00
+ 0.014133000000 4.50
+ 0.016175480000 4.50
+ 0.016175500000 0.00
+ 0.016181480000 0.00
+ 0.016181500000 4.50
+ 0.018227480000 4.50
+ 0.018227500000 0.00
+ 0.018233480000 0.00
+ 0.018233500000 4.50
+ 0.020271480000 4.50
+ 0.020271500000 0.00
+ 0.020277480000 0.00
+ 0.020277500000 4.50
+ 0.022318480000 4.50
+ 0.022318500000 0.00
+ 0.022324480000 0.00
+ 0.022324500000 4.50
+ 0.024383480000 4.50
+ 0.024383500000 0.00
+ 0.024389480000 0.00
+ 0.024389500000 4.50
+ 0.026425480000 4.50
+ 0.026425500000 0.00
+ 0.026431480000 0.00
+ 0.026431500000 4.50
+ 0.028462480000 4.50
+ 0.028462500000 0.00
+ 0.028468480000 0.00
+ 0.028468500000 4.50
+ 0.030511480000 4.50
+ 0.030511500000 0.00
+ 0.030517480000 0.00
+ 0.030517500000 4.50
+ 0.032559480000 4.50
+ 0.032559500000 0.00
+ 0.032565480000 0.00
+ 0.032565500000 4.50
+ 0.034610980000 4.50
+ 0.034611000000 0.00
+ 0.034616980000 0.00
+ 0.034617000000 4.50
+ 0.036654980000 4.50
+ 0.036655000000 0.00
+ 0.036660980000 0.00
+ 0.036661000000 4.50
+ 0.038703980000 4.50
+ 0.038704000000 0.00
+ 0.038709980000 0.00
+ 0.038710000000 4.50
+ 0.040766980000 4.50
+ 0.040767000000 0.00
+ 0.040772980000 0.00
+ 0.040773000000 4.50
+ 0.042812980000 4.50
+ 0.042813000000 0.00
+ 0.042818980000 0.00
+ 0.042819000000 4.50
+ 0.044846480000 4.50
+ 0.044846500000 0.00
+ 0.044852480000 0.00
+ 0.044852500000 4.50
+ 0.046895480000 4.50
+ 0.046895500000 0.00
+ 0.046901480000 0.00
+ 0.046901500000 4.50
+ 0.048943480000 4.50
+ 0.048943500000 0.00
+ 0.048949480000 0.00
+ 0.048949500000 4.50
+ 0.050995980000 4.50
+ 0.050996000000 0.00
+ 0.051001980000 0.00
+ 0.051002000000 4.50
+ 0.053039980000 4.50
+ 0.053040000000 0.00
+ 0.053045980000 0.00
+ 0.053046000000 4.50
+ 0.055088480000 4.50
+ 0.055088500000 0.00
+ 0.055094480000 0.00
+ 0.055094500000 4.50
+ 0.057151980000 4.50
+ 0.057152000000 0.00
+ 0.057157980000 0.00
+ 0.057158000000 4.50
+ 0.059196980000 4.50
+ 0.059197000000 0.00
+ 0.059202980000 0.00
+ 0.059203000000 4.50
+ 0.061233980000 4.50
+ 0.061234000000 0.00
+ 0.061239980000 0.00
+ 0.061240000000 4.50
+ 0.063279480000 4.50
+ 0.063279500000 0.00
+ 0.063285480000 0.00
+ 0.063285500000 4.50
+ 0.065326480000 4.50
+ 0.065326500000 0.00
+ 0.065332480000 0.00
+ 0.065332500000 4.50
+ 0.067375480000 4.50
+ 0.067375500000 0.00
+ 0.067381480000 0.00
+ 0.067381500000 4.50
+ 0.069422980000 4.50
+ 0.069423000000 0.00
+ 0.069428980000 0.00
+ 0.069429000000 4.50
+ 0.071471980000 4.50
+ 0.071472000000 0.00
+ 0.071477980000 0.00
+ 0.071478000000 4.50
+ 0.073590980000 4.50
+ 0.073591000000 0.00
+ 0.073596980000 0.00
+ 0.073597000000 4.50
+ 0.075573980000 4.50
+ 0.075574000000 0.00
+ 0.075579980000 0.00
+ 0.075580000000 4.50
+ 0.077614480000 4.50
+ 0.077614500000 0.00
+ 0.077620480000 0.00
+ 0.077620500000 4.50
+ 0.079663980000 4.50
+ 0.079664000000 0.00
+ 0.079669980000 0.00
+ 0.079670000000 4.50
+ 0.081710480000 4.50
+ 0.081710500000 0.00
+ 0.081716480000 0.00
+ 0.081716500000 4.50
+ 0.083759980000 4.50
+ 0.083760000000 0.00
+ 0.083765980000 0.00
+ 0.083766000000 4.50
+ 0.085806480000 4.50
+ 0.085806500000 0.00
+ 0.085812480000 0.00
+ 0.085812500000 4.50
+ 0.087854980000 4.50
+ 0.087855000000 0.00
+ 0.087860980000 0.00
+ 0.087861000000 4.50
+ 0.089919980000 4.50
+ 0.089920000000 0.00
+ 0.089925980000 0.00
+ 0.089926000000 4.50
+ 0.091956480000 4.50
+ 0.091956500000 0.00
+ 0.091962480000 0.00
+ 0.091962500000 4.50
+ 0.093998980000 4.50
+ 0.093999000000 0.00
+ 0.094004980000 0.00
+ 0.094005000000 4.50
+ 0.096051480000 4.50
+ 0.096051500000 0.00
+ 0.096057480000 0.00
+ 0.096057500000 4.50
+ 0.098096980000 4.50
+ 0.098097000000 0.00
+ 0.098102980000 0.00
+ 0.098103000000 4.50
+ 0.100143980000 4.50
+ 0.100144000000 0.00
+ 0.100149980000 0.00
+ 0.100150000000 4.50
+ 0.102190480000 4.50
+ 0.102190500000 0.00
+ 0.102196480000 0.00
+ 0.102196500000 4.50
+ 0.104240480000 4.50
+ 0.104240500000 0.00
+ 0.104246480000 0.00
+ 0.104246500000 4.50
+ 0.106304480000 4.50
+ 0.106304500000 0.00
+ 0.106310480000 0.00
+ 0.106310500000 4.50
+ 0.108343480000 4.50
+ 0.108343500000 0.00
+ 0.108349480000 0.00
+ 0.108349500000 4.50
+ 0.110383980000 4.50
+ 0.110384000000 0.00
+ 0.110389980000 0.00
+ 0.110390000000 4.50
+ 0.112430980000 4.50
+ 0.112431000000 0.00
+ 0.112436980000 0.00
+ 0.112437000000 4.50
+ 0.114479480000 4.50
+ 0.114479500000 0.00
+ 0.114485480000 0.00
+ 0.114485500000 4.50
+ 0.116526480000 4.50
+ 0.116526500000 0.00
+ 0.116532480000 0.00
+ 0.116532500000 4.50
+ 0.118574980000 4.50
+ 0.118575000000 0.00
+ 0.118580980000 0.00
+ 0.118581000000 4.50
+ 0.120623980000 4.50
+ 0.120624000000 0.00
+ 0.120629980000 0.00
+ 0.120630000000 4.50
+ 0.122686980000 4.50
+ 0.122687000000 0.00
+ 0.122692980000 0.00
+ 0.122693000000 4.50
+ 0.124724980000 4.50
+ 0.124725000000 0.00
+ 0.124730980000 0.00
+ 0.124731000000 4.50
+ 0.126771980000 4.50
+ 0.126772000000 0.00
+ 0.126777980000 0.00
+ 0.126778000000 4.50
+ 0.128815980000 4.50
+ 0.128816000000 0.00
+ 0.128821980000 0.00
+ 0.128822000000 4.50
+ 0.130863480000 4.50
+ 0.130863500000 0.00
+ 0.130869480000 0.00
+ 0.130869500000 4.50
+ 0.132911480000 4.50
+ 0.132911500000 0.00
+ 0.132917480000 0.00
+ 0.132917500000 4.50
+ 0.134963480000 4.50
+ 0.134963500000 0.00
+ 0.134969480000 0.00
+ 0.134969500000 4.50
+ 0.137006480000 4.50
+ 0.137006500000 0.00
+ 0.137012480000 0.00
+ 0.137012500000 4.50
+ 0.139126980000 4.50
+ 0.139127000000 0.00
+ 0.139132980000 0.00
+ 0.139133000000 4.50
+ 0.141109980000 4.50
+ 0.141110000000 0.00
+ 0.141115980000 0.00
+ 0.141116000000 4.50
+ 0.143155480000 4.50
+ 0.143155500000 0.00
+ 0.143161480000 0.00
+ 0.143161500000 4.50
+ 0.145198480000 4.50
+ 0.145198500000 0.00
+ 0.145204480000 0.00
+ 0.145204500000 4.50
+ 0.147247480000 4.50
+ 0.147247500000 0.00
+ 0.147253480000 0.00
+ 0.147253500000 4.50
+ 0.149294480000 4.50
+ 0.149294500000 0.00
+ 0.149300480000 0.00
+ 0.149300500000 4.50
+ 0.151349980000 4.50
+ 0.151350000000 0.00
+ 0.151355980000 0.00
+ 0.151356000000 4.50
+ 0.153392980000 4.50
+ 0.153393000000 0.00
+ 0.153398980000 0.00
+ 0.153399000000 4.50
+ 0.155455980000 4.50
+ 0.155456000000 0.00
+ 0.155461980000 0.00
+ 0.155462000000 4.50
+ 0.157492980000 4.50
+ 0.157493000000 0.00
+ 0.157498980000 0.00
+ 0.157499000000 4.50
+ 0.159539480000 4.50
+ 0.159539500000 0.00
+ 0.159545480000 0.00
+ 0.159545500000 4.50
+ 0.161582480000 4.50
+ 0.161582500000 0.00
+ 0.161588480000 0.00
+ 0.161588500000 4.50
+ 0.163630480000 4.50
+ 0.163630500000 0.00
+ 0.163636480000 0.00
+ 0.163636500000 4.50
+ 0.165682980000 4.50
+ 0.165683000000 0.00
+ 0.165688980000 0.00
+ 0.165689000000 4.50
+ 0.167731480000 4.50
+ 0.167731500000 0.00
+ 0.167737480000 0.00
+ 0.167737500000 4.50
+ 0.169775480000 4.50
+ 0.169775500000 0.00
+ 0.169781480000 0.00
+ 0.169781500000 4.50
+ 0.171839480000 4.50
+ 0.171839500000 0.00
+ 0.171845480000 0.00
+ 0.171845500000 4.50
+ 0.173878980000 4.50
+ 0.173879000000 0.00
+ 0.173884980000 0.00
+ 0.173885000000 4.50
+ 0.175923980000 4.50
+ 0.175924000000 0.00
+ 0.175929980000 0.00
+ 0.175930000000 4.50
+ 0.177970980000 4.50
+ 0.177971000000 0.00
+ 0.177976980000 0.00
+ 0.177977000000 4.50
+ 0.180014480000 4.50
+ 0.180014500000 0.00
+ 0.180020480000 0.00
+ 0.180020500000 4.50
+ 0.182063480000 4.50
+ 0.182063500000 0.00
+ 0.182069480000 0.00
+ 0.182069500000 4.50
+ 0.184114980000 4.50
+ 0.184115000000 0.00
+ 0.184120980000 0.00
+ 0.184121000000 4.50
+ 0.186158980000 4.50
+ 0.186159000000 0.00
+ 0.186164980000 0.00
+ 0.186165000000 4.50
+ 0.188223480000 4.50
+ 0.188223500000 0.00
+ 0.188229480000 0.00
+ 0.188229500000 4.50
+ 0.190260480000 4.50
+ 0.190260500000 0.00
+ 0.190266480000 0.00
+ 0.190266500000 4.50
+ 0.192306480000 4.50
+ 0.192306500000 0.00
+ 0.192312480000 0.00
+ 0.192312500000 4.50
+ 0.194350980000 4.50
+ 0.194351000000 0.00
+ 0.194356980000 0.00
+ 0.194357000000 4.50
+ 0.196398980000 4.50
+ 0.196399000000 0.00
+ 0.196404980000 0.00
+ 0.196405000000 4.50
+ 0.198446480000 4.50
+ 0.198446500000 0.00
+ 0.198452480000 0.00
+ 0.198452500000 4.50
+ 0.200494480000 4.50
+ 0.200494500000 0.00
+ 0.200500480000 0.00
+ 0.200500500000 4.50
+ 0.202543480000 4.50
+ 0.202543500000 0.00
+ 0.202549480000 0.00
+ 0.202549500000 4.50
+ 0.204663480000 4.50
+ 0.204663500000 0.00
+ 0.204669480000 0.00
+ 0.204669500000 4.50
+ 0.206644980000 4.50
+ 0.206645000000 0.00
+ 0.206650980000 0.00
+ 0.206651000000 4.50
+ 0.208686480000 4.50
+ 0.208686500000 0.00
+ 0.208692480000 0.00
+ 0.208692500000 4.50
+ 0.210735480000 4.50
+ 0.210735500000 0.00
+ 0.210741480000 0.00
+ 0.210741500000 4.50
+ 0.212782980000 4.50
+ 0.212783000000 0.00
+ 0.212788980000 0.00
+ 0.212789000000 4.50
+ 0.214830980000 4.50
+ 0.214831000000 0.00
+ 0.214836980000 0.00
+ 0.214837000000 4.50
+ 0.216878480000 4.50
+ 0.216878500000 0.00
+ 0.216884480000 0.00
+ 0.216884500000 4.50
+ 0.218927980000 4.50
+ 0.218928000000 0.00
+ 0.218933980000 0.00
+ 0.218934000000 4.50
+ 0.220992480000 4.50
+ 0.220992500000 0.00
+ 0.220998480000 0.00
+ 0.220998500000 4.50
+ 0.223028480000 4.50
+ 0.223028500000 0.00
+ 0.223034480000 0.00
+ 0.223034500000 4.50
+ 0.225070480000 4.50
+ 0.225070500000 0.00
+ 0.225076480000 0.00
+ 0.225076500000 4.50
+ 0.227118980000 4.50
+ 0.227119000000 0.00
+ 0.227124980000 0.00
+ 0.227125000000 4.50
+ 0.229166980000 4.50
+ 0.229167000000 0.00
+ 0.229172980000 0.00
+ 0.229173000000 4.50
+ 0.231214480000 4.50
+ 0.231214500000 0.00
+ 0.231220480000 0.00
+ 0.231220500000 4.50
+ 0.233263980000 4.50
+ 0.233264000000 0.00
+ 0.233269980000 0.00
+ 0.233270000000 4.50
+ 0.235310480000 4.50
+ 0.235310500000 0.00
+ 0.235316480000 0.00
+ 0.235316500000 4.50
+ 0.237374980000 4.50
+ 0.237375000000 0.00
+ 0.237380980000 0.00
+ 0.237381000000 4.50
+ 0.239413480000 4.50
+ 0.239413500000 0.00
+ 0.239419480000 0.00
+ 0.239419500000 4.50
+ 0.241454480000 4.50
+ 0.241454500000 0.00
+ 0.241460480000 0.00
+ 0.241460500000 4.50
+ 0.243503980000 4.50
+ 0.243504000000 0.00
+ 0.243509980000 0.00
+ 0.243510000000 4.50
+ 0.245550980000 4.50
+ 0.245551000000 0.00
+ 0.245556980000 0.00
+ 0.245557000000 4.50
+ 0.247599480000 4.50
+ 0.247599500000 0.00
+ 0.247605480000 0.00
+ 0.247605500000 4.50
+ 0.249646480000 4.50
+ 0.249646500000 0.00
+ 0.249652480000 0.00
+ 0.249652500000 4.50
+ 0.251701480000 4.50
+ 0.251701500000 0.00
+ 0.251707480000 0.00
+ 0.251707500000 4.50
+ 0.253761980000 4.50
+ 0.253762000000 0.00
+ 0.253767980000 0.00
+ 0.253768000000 4.50
+ 0.255796480000 4.50
+ 0.255796500000 0.00
+ 0.255802480000 0.00
+ 0.255802500000 4.50
+ 0.257838980000 4.50
+ 0.257839000000 0.00
+ 0.257844980000 0.00
+ 0.257845000000 4.50
+ 0.259891480000 4.50
+ 0.259891500000 0.00
+ 0.259897480000 0.00
+ 0.259897500000 4.50
+ 0.261935980000 4.50
+ 0.261936000000 0.00
+ 0.261941980000 0.00
+ 0.261942000000 4.50
+ 0.263982480000 4.50
+ 0.263982500000 0.00
+ 0.263988480000 0.00
+ 0.263988500000 4.50
+ 0.266031480000 4.50
+ 0.266031500000 0.00
+ 0.266037480000 0.00
+ 0.266037500000 4.50
+ 0.268083480000 4.50
+ 0.268083500000 0.00
+ 0.268089480000 0.00
+ 0.268089500000 4.50
+ 0.270198980000 4.50
+ 0.270199000000 0.00
+ 0.270204980000 0.00
+ 0.270205000000 4.50
+ 0.272181980000 4.50
+ 0.272182000000 0.00
+ 0.272187980000 0.00
+ 0.272188000000 4.50
+ 0.274222980000 4.50
+ 0.274223000000 0.00
+ 0.274228980000 0.00
+ 0.274229000000 4.50
+ 0.276275980000 4.50
+ 0.276276000000 0.00
+ 0.276281980000 0.00
+ 0.276282000000 4.50
+ 0.278321480000 4.50
+ 0.278321500000 0.00
+ 0.278327480000 0.00
+ 0.278327500000 4.50
+ 0.280367480000 4.50
+ 0.280367500000 0.00
+ 0.280373480000 0.00
+ 0.280373500000 4.50
+ 0.282415980000 4.50
+ 0.282416000000 0.00
+ 0.282421980000 0.00
+ 0.282422000000 4.50
+ 0.284468480000 4.50
+ 0.284468500000 0.00
+ 0.284474480000 0.00
+ 0.284474500000 4.50
+ 0.286527980000 4.50
+ 0.286528000000 0.00
+ 0.286533980000 0.00
+ 0.286534000000 4.50
+ 0.288564980000 4.50
+ 0.288565000000 0.00
+ 0.288570980000 0.00
+ 0.288571000000 4.50
+ 0.290607980000 4.50
+ 0.290608000000 0.00
+ 0.290613980000 0.00
+ 0.290614000000 4.50
+ 0.292659480000 4.50
+ 0.292659500000 0.00
+ 0.292665480000 0.00
+ 0.292665500000 4.50
+ 0.294702980000 4.50
+ 0.294703000000 0.00
+ 0.294708980000 0.00
+ 0.294709000000 4.50
+ 0.296752980000 4.50
+ 0.296753000000 0.00
+ 0.296758980000 0.00
+ 0.296759000000 4.50
+ 0.298798980000 4.50
+ 0.298799000000 0.00
+ 0.298804980000 0.00
+ 0.298805000000 4.50
+ 0.300851980000 4.50
+ 0.300852000000 0.00
+ 0.300857980000 0.00
+ 0.300858000000 4.50
+ 0.302910980000 4.50
+ 0.302911000000 0.00
+ 0.302916980000 0.00
+ 0.302917000000 4.50
+ 0.304951480000 4.50
+ 0.304951500000 0.00
+ 0.304957480000 0.00
+ 0.304957500000 4.50
+ 0.306992480000 4.50
+ 0.306992500000 0.00
+ 0.306998480000 0.00
+ 0.306998500000 4.50
+ 0.309038980000 4.50
+ 0.309039000000 0.00
+ 0.309044980000 0.00
+ 0.309045000000 4.50
+ 0.311087980000 4.50
+ 0.311088000000 0.00
+ 0.311093980000 0.00
+ 0.311094000000 4.50
+ 0.313134980000 4.50
+ 0.313135000000 0.00
+ 0.313140980000 0.00
+ 0.313141000000 4.50
+ 0.315182480000 4.50
+ 0.315182500000 0.00
+ 0.315188480000 0.00
+ 0.315188500000 4.50
+ 0.317230480000 4.50
+ 0.317230500000 0.00
+ 0.317236480000 0.00
+ 0.317236500000 4.50
+ 0.319295980000 4.50
+ 0.319296000000 0.00
+ 0.319301980000 0.00
+ 0.319302000000 4.50
+ 0.321333480000 4.50
+ 0.321333500000 0.00
+ 0.321339480000 0.00
+ 0.321339500000 4.50
+ 0.323375980000 4.50
+ 0.323376000000 0.00
+ 0.323381980000 0.00
+ 0.323382000000 4.50
+ 0.325423480000 4.50
+ 0.325423500000 0.00
+ 0.325429480000 0.00
+ 0.325429500000 4.50
+ 0.327470980000 4.50
+ 0.327471000000 0.00
+ 0.327476980000 0.00
+ 0.327477000000 4.50
+ 0.329519980000 4.50
+ 0.329520000000 0.00
+ 0.329525980000 0.00
+ 0.329526000000 4.50
+ 0.331567480000 4.50
+ 0.331567500000 0.00
+ 0.331573480000 0.00
+ 0.331573500000 4.50
+ 0.333614980000 4.50
+ 0.333615000000 0.00
+ 0.333620980000 0.00
+ 0.333621000000 4.50
+ 0.335734980000 4.50
+ 0.335735000000 0.00
+ 0.335740980000 0.00
+ 0.335741000000 4.50
+ 0.337720480000 4.50
+ 0.337720500000 0.00
+ 0.337726480000 0.00
+ 0.337726500000 4.50
+ 0.339759480000 4.50
+ 0.339759500000 0.00
+ 0.339765480000 0.00
+ 0.339765500000 4.50
+ 0.341806480000 4.50
+ 0.341806500000 0.00
+ 0.341812480000 0.00
+ 0.341812500000 4.50
+ 0.343856980000 4.50
+ 0.343857000000 0.00
+ 0.343862980000 0.00
+ 0.343863000000 4.50
+ 0.345902980000 4.50
+ 0.345903000000 0.00
+ 0.345908980000 0.00
+ 0.345909000000 4.50
+ 0.347951980000 4.50
+ 0.347952000000 0.00
+ 0.347957980000 0.00
+ 0.347958000000 4.50
+ 0.349999980000 4.50
+ 0.350000000000 0.00
+ 0.350000020000 0.00
+ 0.370000000000 0.00
+ )
Vdriverow6 row6cmd 0 PWL(
+ 0.000000000000 4.50
+ 0.001840980000 4.50
+ 0.001841000000 0.00
+ 0.001846980000 0.00
+ 0.001847000000 4.50
+ 0.003888980000 4.50
+ 0.003889000000 0.00
+ 0.003894980000 0.00
+ 0.003895000000 4.50
+ 0.005934480000 4.50
+ 0.005934500000 0.00
+ 0.005940480000 0.00
+ 0.005940500000 4.50
+ 0.008054980000 4.50
+ 0.008055000000 0.00
+ 0.010047980000 0.00
+ 0.010048000000 4.50
+ 0.012078480000 4.50
+ 0.012078500000 0.00
+ 0.012084480000 0.00
+ 0.012084500000 4.50
+ 0.014126980000 4.50
+ 0.014127000000 0.00
+ 0.014132980000 0.00
+ 0.014133000000 4.50
+ 0.016175480000 4.50
+ 0.016175500000 0.00
+ 0.016181480000 0.00
+ 0.016181500000 4.50
+ 0.018227480000 4.50
+ 0.018227500000 0.00
+ 0.018233480000 0.00
+ 0.018233500000 4.50
+ 0.020271480000 4.50
+ 0.020271500000 0.00
+ 0.020277480000 0.00
+ 0.020277500000 4.50
+ 0.022318480000 4.50
+ 0.022318500000 0.00
+ 0.022324480000 0.00
+ 0.022324500000 4.50
+ 0.024383480000 4.50
+ 0.024383500000 0.00
+ 0.026431480000 0.00
+ 0.026431500000 4.50
+ 0.028462480000 4.50
+ 0.028462500000 0.00
+ 0.028468480000 0.00
+ 0.028468500000 4.50
+ 0.030511480000 4.50
+ 0.030511500000 0.00
+ 0.030517480000 0.00
+ 0.030517500000 4.50
+ 0.032559480000 4.50
+ 0.032559500000 0.00
+ 0.032565480000 0.00
+ 0.032565500000 4.50
+ 0.034610980000 4.50
+ 0.034611000000 0.00
+ 0.034616980000 0.00
+ 0.034617000000 4.50
+ 0.036654980000 4.50
+ 0.036655000000 0.00
+ 0.036660980000 0.00
+ 0.036661000000 4.50
+ 0.038703980000 4.50
+ 0.038704000000 0.00
+ 0.038709980000 0.00
+ 0.038710000000 4.50
+ 0.040766980000 4.50
+ 0.040767000000 0.00
+ 0.042818980000 0.00
+ 0.042819000000 4.50
+ 0.044846480000 4.50
+ 0.044846500000 0.00
+ 0.044852480000 0.00
+ 0.044852500000 4.50
+ 0.046895480000 4.50
+ 0.046895500000 0.00
+ 0.046901480000 0.00
+ 0.046901500000 4.50
+ 0.048943480000 4.50
+ 0.048943500000 0.00
+ 0.048949480000 0.00
+ 0.048949500000 4.50
+ 0.050995980000 4.50
+ 0.050996000000 0.00
+ 0.051001980000 0.00
+ 0.051002000000 4.50
+ 0.053039980000 4.50
+ 0.053040000000 0.00
+ 0.053045980000 0.00
+ 0.053046000000 4.50
+ 0.055088480000 4.50
+ 0.055088500000 0.00
+ 0.055094480000 0.00
+ 0.055094500000 4.50
+ 0.057151980000 4.50
+ 0.057152000000 0.00
+ 0.059202980000 0.00
+ 0.059203000000 4.50
+ 0.061233980000 4.50
+ 0.061234000000 0.00
+ 0.061239980000 0.00
+ 0.061240000000 4.50
+ 0.063279480000 4.50
+ 0.063279500000 0.00
+ 0.063285480000 0.00
+ 0.063285500000 4.50
+ 0.065326480000 4.50
+ 0.065326500000 0.00
+ 0.065332480000 0.00
+ 0.065332500000 4.50
+ 0.067375480000 4.50
+ 0.067375500000 0.00
+ 0.067381480000 0.00
+ 0.067381500000 4.50
+ 0.069422980000 4.50
+ 0.069423000000 0.00
+ 0.069428980000 0.00
+ 0.069429000000 4.50
+ 0.071471980000 4.50
+ 0.071472000000 0.00
+ 0.071477980000 0.00
+ 0.071478000000 4.50
+ 0.073590980000 4.50
+ 0.073591000000 0.00
+ 0.075579980000 0.00
+ 0.075580000000 4.50
+ 0.077614480000 4.50
+ 0.077614500000 0.00
+ 0.077620480000 0.00
+ 0.077620500000 4.50
+ 0.079663980000 4.50
+ 0.079664000000 0.00
+ 0.079669980000 0.00
+ 0.079670000000 4.50
+ 0.081710480000 4.50
+ 0.081710500000 0.00
+ 0.081716480000 0.00
+ 0.081716500000 4.50
+ 0.083759980000 4.50
+ 0.083760000000 0.00
+ 0.083765980000 0.00
+ 0.083766000000 4.50
+ 0.085806480000 4.50
+ 0.085806500000 0.00
+ 0.085812480000 0.00
+ 0.085812500000 4.50
+ 0.087854980000 4.50
+ 0.087855000000 0.00
+ 0.087860980000 0.00
+ 0.087861000000 4.50
+ 0.089919980000 4.50
+ 0.089920000000 0.00
+ 0.091962480000 0.00
+ 0.091962500000 4.50
+ 0.093998980000 4.50
+ 0.093999000000 0.00
+ 0.094004980000 0.00
+ 0.094005000000 4.50
+ 0.096051480000 4.50
+ 0.096051500000 0.00
+ 0.096057480000 0.00
+ 0.096057500000 4.50
+ 0.098096980000 4.50
+ 0.098097000000 0.00
+ 0.098102980000 0.00
+ 0.098103000000 4.50
+ 0.100143980000 4.50
+ 0.100144000000 0.00
+ 0.100149980000 0.00
+ 0.100150000000 4.50
+ 0.102190480000 4.50
+ 0.102190500000 0.00
+ 0.102196480000 0.00
+ 0.102196500000 4.50
+ 0.104240480000 4.50
+ 0.104240500000 0.00
+ 0.104246480000 0.00
+ 0.104246500000 4.50
+ 0.106304480000 4.50
+ 0.106304500000 0.00
+ 0.108349480000 0.00
+ 0.108349500000 4.50
+ 0.110383980000 4.50
+ 0.110384000000 0.00
+ 0.110389980000 0.00
+ 0.110390000000 4.50
+ 0.112430980000 4.50
+ 0.112431000000 0.00
+ 0.112436980000 0.00
+ 0.112437000000 4.50
+ 0.114479480000 4.50
+ 0.114479500000 0.00
+ 0.114485480000 0.00
+ 0.114485500000 4.50
+ 0.116526480000 4.50
+ 0.116526500000 0.00
+ 0.116532480000 0.00
+ 0.116532500000 4.50
+ 0.118574980000 4.50
+ 0.118575000000 0.00
+ 0.118580980000 0.00
+ 0.118581000000 4.50
+ 0.120623980000 4.50
+ 0.120624000000 0.00
+ 0.120629980000 0.00
+ 0.120630000000 4.50
+ 0.122686980000 4.50
+ 0.122687000000 0.00
+ 0.124730980000 0.00
+ 0.124731000000 4.50
+ 0.126771980000 4.50
+ 0.126772000000 0.00
+ 0.126777980000 0.00
+ 0.126778000000 4.50
+ 0.128815980000 4.50
+ 0.128816000000 0.00
+ 0.128821980000 0.00
+ 0.128822000000 4.50
+ 0.130863480000 4.50
+ 0.130863500000 0.00
+ 0.130869480000 0.00
+ 0.130869500000 4.50
+ 0.132911480000 4.50
+ 0.132911500000 0.00
+ 0.132917480000 0.00
+ 0.132917500000 4.50
+ 0.134963480000 4.50
+ 0.134963500000 0.00
+ 0.134969480000 0.00
+ 0.134969500000 4.50
+ 0.137006480000 4.50
+ 0.137006500000 0.00
+ 0.137012480000 0.00
+ 0.137012500000 4.50
+ 0.139126980000 4.50
+ 0.139127000000 0.00
+ 0.141115980000 0.00
+ 0.141116000000 4.50
+ 0.143155480000 4.50
+ 0.143155500000 0.00
+ 0.143161480000 0.00
+ 0.143161500000 4.50
+ 0.145198480000 4.50
+ 0.145198500000 0.00
+ 0.145204480000 0.00
+ 0.145204500000 4.50
+ 0.147247480000 4.50
+ 0.147247500000 0.00
+ 0.147253480000 0.00
+ 0.147253500000 4.50
+ 0.149294480000 4.50
+ 0.149294500000 0.00
+ 0.149300480000 0.00
+ 0.149300500000 4.50
+ 0.151349980000 4.50
+ 0.151350000000 0.00
+ 0.151355980000 0.00
+ 0.151356000000 4.50
+ 0.153392980000 4.50
+ 0.153393000000 0.00
+ 0.153398980000 0.00
+ 0.153399000000 4.50
+ 0.155455980000 4.50
+ 0.155456000000 0.00
+ 0.157498980000 0.00
+ 0.157499000000 4.50
+ 0.159539480000 4.50
+ 0.159539500000 0.00
+ 0.159545480000 0.00
+ 0.159545500000 4.50
+ 0.161582480000 4.50
+ 0.161582500000 0.00
+ 0.161588480000 0.00
+ 0.161588500000 4.50
+ 0.163630480000 4.50
+ 0.163630500000 0.00
+ 0.163636480000 0.00
+ 0.163636500000 4.50
+ 0.165682980000 4.50
+ 0.165683000000 0.00
+ 0.165688980000 0.00
+ 0.165689000000 4.50
+ 0.167731480000 4.50
+ 0.167731500000 0.00
+ 0.167737480000 0.00
+ 0.167737500000 4.50
+ 0.169775480000 4.50
+ 0.169775500000 0.00
+ 0.169781480000 0.00
+ 0.169781500000 4.50
+ 0.171839480000 4.50
+ 0.171839500000 0.00
+ 0.173884980000 0.00
+ 0.173885000000 4.50
+ 0.175923980000 4.50
+ 0.175924000000 0.00
+ 0.175929980000 0.00
+ 0.175930000000 4.50
+ 0.177970980000 4.50
+ 0.177971000000 0.00
+ 0.177976980000 0.00
+ 0.177977000000 4.50
+ 0.180014480000 4.50
+ 0.180014500000 0.00
+ 0.180020480000 0.00
+ 0.180020500000 4.50
+ 0.182063480000 4.50
+ 0.182063500000 0.00
+ 0.182069480000 0.00
+ 0.182069500000 4.50
+ 0.184114980000 4.50
+ 0.184115000000 0.00
+ 0.184120980000 0.00
+ 0.184121000000 4.50
+ 0.186158980000 4.50
+ 0.186159000000 0.00
+ 0.186164980000 0.00
+ 0.186165000000 4.50
+ 0.188223480000 4.50
+ 0.188223500000 0.00
+ 0.190266480000 0.00
+ 0.190266500000 4.50
+ 0.192306480000 4.50
+ 0.192306500000 0.00
+ 0.192312480000 0.00
+ 0.192312500000 4.50
+ 0.194350980000 4.50
+ 0.194351000000 0.00
+ 0.194356980000 0.00
+ 0.194357000000 4.50
+ 0.196398980000 4.50
+ 0.196399000000 0.00
+ 0.196404980000 0.00
+ 0.196405000000 4.50
+ 0.198446480000 4.50
+ 0.198446500000 0.00
+ 0.198452480000 0.00
+ 0.198452500000 4.50
+ 0.200494480000 4.50
+ 0.200494500000 0.00
+ 0.200500480000 0.00
+ 0.200500500000 4.50
+ 0.202543480000 4.50
+ 0.202543500000 0.00
+ 0.202549480000 0.00
+ 0.202549500000 4.50
+ 0.204663480000 4.50
+ 0.204663500000 0.00
+ 0.206650980000 0.00
+ 0.206651000000 4.50
+ 0.208686480000 4.50
+ 0.208686500000 0.00
+ 0.208692480000 0.00
+ 0.208692500000 4.50
+ 0.210735480000 4.50
+ 0.210735500000 0.00
+ 0.210741480000 0.00
+ 0.210741500000 4.50
+ 0.212782980000 4.50
+ 0.212783000000 0.00
+ 0.212788980000 0.00
+ 0.212789000000 4.50
+ 0.214830980000 4.50
+ 0.214831000000 0.00
+ 0.214836980000 0.00
+ 0.214837000000 4.50
+ 0.216878480000 4.50
+ 0.216878500000 0.00
+ 0.216884480000 0.00
+ 0.216884500000 4.50
+ 0.218927980000 4.50
+ 0.218928000000 0.00
+ 0.218933980000 0.00
+ 0.218934000000 4.50
+ 0.220992480000 4.50
+ 0.220992500000 0.00
+ 0.223034480000 0.00
+ 0.223034500000 4.50
+ 0.225070480000 4.50
+ 0.225070500000 0.00
+ 0.225076480000 0.00
+ 0.225076500000 4.50
+ 0.227118980000 4.50
+ 0.227119000000 0.00
+ 0.227124980000 0.00
+ 0.227125000000 4.50
+ 0.229166980000 4.50
+ 0.229167000000 0.00
+ 0.229172980000 0.00
+ 0.229173000000 4.50
+ 0.231214480000 4.50
+ 0.231214500000 0.00
+ 0.231220480000 0.00
+ 0.231220500000 4.50
+ 0.233263980000 4.50
+ 0.233264000000 0.00
+ 0.233269980000 0.00
+ 0.233270000000 4.50
+ 0.235310480000 4.50
+ 0.235310500000 0.00
+ 0.235316480000 0.00
+ 0.235316500000 4.50
+ 0.237374980000 4.50
+ 0.237375000000 0.00
+ 0.239419480000 0.00
+ 0.239419500000 4.50
+ 0.241454480000 4.50
+ 0.241454500000 0.00
+ 0.241460480000 0.00
+ 0.241460500000 4.50
+ 0.243503980000 4.50
+ 0.243504000000 0.00
+ 0.243509980000 0.00
+ 0.243510000000 4.50
+ 0.245550980000 4.50
+ 0.245551000000 0.00
+ 0.245556980000 0.00
+ 0.245557000000 4.50
+ 0.247599480000 4.50
+ 0.247599500000 0.00
+ 0.247605480000 0.00
+ 0.247605500000 4.50
+ 0.249646480000 4.50
+ 0.249646500000 0.00
+ 0.249652480000 0.00
+ 0.249652500000 4.50
+ 0.251701480000 4.50
+ 0.251701500000 0.00
+ 0.251707480000 0.00
+ 0.251707500000 4.50
+ 0.253761980000 4.50
+ 0.253762000000 0.00
+ 0.255802480000 0.00
+ 0.255802500000 4.50
+ 0.257838980000 4.50
+ 0.257839000000 0.00
+ 0.257844980000 0.00
+ 0.257845000000 4.50
+ 0.259891480000 4.50
+ 0.259891500000 0.00
+ 0.259897480000 0.00
+ 0.259897500000 4.50
+ 0.261935980000 4.50
+ 0.261936000000 0.00
+ 0.261941980000 0.00
+ 0.261942000000 4.50
+ 0.263982480000 4.50
+ 0.263982500000 0.00
+ 0.263988480000 0.00
+ 0.263988500000 4.50
+ 0.266031480000 4.50
+ 0.266031500000 0.00
+ 0.266037480000 0.00
+ 0.266037500000 4.50
+ 0.268083480000 4.50
+ 0.268083500000 0.00
+ 0.268089480000 0.00
+ 0.268089500000 4.50
+ 0.270198980000 4.50
+ 0.270199000000 0.00
+ 0.272187980000 0.00
+ 0.272188000000 4.50
+ 0.274222980000 4.50
+ 0.274223000000 0.00
+ 0.274228980000 0.00
+ 0.274229000000 4.50
+ 0.276275980000 4.50
+ 0.276276000000 0.00
+ 0.276281980000 0.00
+ 0.276282000000 4.50
+ 0.278321480000 4.50
+ 0.278321500000 0.00
+ 0.278327480000 0.00
+ 0.278327500000 4.50
+ 0.280367480000 4.50
+ 0.280367500000 0.00
+ 0.280373480000 0.00
+ 0.280373500000 4.50
+ 0.282415980000 4.50
+ 0.282416000000 0.00
+ 0.282421980000 0.00
+ 0.282422000000 4.50
+ 0.284468480000 4.50
+ 0.284468500000 0.00
+ 0.284474480000 0.00
+ 0.284474500000 4.50
+ 0.286527980000 4.50
+ 0.286528000000 0.00
+ 0.288570980000 0.00
+ 0.288571000000 4.50
+ 0.290607980000 4.50
+ 0.290608000000 0.00
+ 0.290613980000 0.00
+ 0.290614000000 4.50
+ 0.292659480000 4.50
+ 0.292659500000 0.00
+ 0.292665480000 0.00
+ 0.292665500000 4.50
+ 0.294702980000 4.50
+ 0.294703000000 0.00
+ 0.294708980000 0.00
+ 0.294709000000 4.50
+ 0.296752980000 4.50
+ 0.296753000000 0.00
+ 0.296758980000 0.00
+ 0.296759000000 4.50
+ 0.298798980000 4.50
+ 0.298799000000 0.00
+ 0.298804980000 0.00
+ 0.298805000000 4.50
+ 0.300851980000 4.50
+ 0.300852000000 0.00
+ 0.300857980000 0.00
+ 0.300858000000 4.50
+ 0.302910980000 4.50
+ 0.302911000000 0.00
+ 0.304957480000 0.00
+ 0.304957500000 4.50
+ 0.306992480000 4.50
+ 0.306992500000 0.00
+ 0.306998480000 0.00
+ 0.306998500000 4.50
+ 0.309038980000 4.50
+ 0.309039000000 0.00
+ 0.309044980000 0.00
+ 0.309045000000 4.50
+ 0.311087980000 4.50
+ 0.311088000000 0.00
+ 0.311093980000 0.00
+ 0.311094000000 4.50
+ 0.313134980000 4.50
+ 0.313135000000 0.00
+ 0.313140980000 0.00
+ 0.313141000000 4.50
+ 0.315182480000 4.50
+ 0.315182500000 0.00
+ 0.315188480000 0.00
+ 0.315188500000 4.50
+ 0.317230480000 4.50
+ 0.317230500000 0.00
+ 0.317236480000 0.00
+ 0.317236500000 4.50
+ 0.319295980000 4.50
+ 0.319296000000 0.00
+ 0.321339480000 0.00
+ 0.321339500000 4.50
+ 0.323375980000 4.50
+ 0.323376000000 0.00
+ 0.323381980000 0.00
+ 0.323382000000 4.50
+ 0.325423480000 4.50
+ 0.325423500000 0.00
+ 0.325429480000 0.00
+ 0.325429500000 4.50
+ 0.327470980000 4.50
+ 0.327471000000 0.00
+ 0.327476980000 0.00
+ 0.327477000000 4.50
+ 0.329519980000 4.50
+ 0.329520000000 0.00
+ 0.329525980000 0.00
+ 0.329526000000 4.50
+ 0.331567480000 4.50
+ 0.331567500000 0.00
+ 0.331573480000 0.00
+ 0.331573500000 4.50
+ 0.333614980000 4.50
+ 0.333615000000 0.00
+ 0.333620980000 0.00
+ 0.333621000000 4.50
+ 0.335734980000 4.50
+ 0.335735000000 0.00
+ 0.337726480000 0.00
+ 0.337726500000 4.50
+ 0.339759480000 4.50
+ 0.339759500000 0.00
+ 0.339765480000 0.00
+ 0.339765500000 4.50
+ 0.341806480000 4.50
+ 0.341806500000 0.00
+ 0.341812480000 0.00
+ 0.341812500000 4.50
+ 0.343856980000 4.50
+ 0.343857000000 0.00
+ 0.343862980000 0.00
+ 0.343863000000 4.50
+ 0.345902980000 4.50
+ 0.345903000000 0.00
+ 0.345908980000 0.00
+ 0.345909000000 4.50
+ 0.347951980000 4.50
+ 0.347952000000 0.00
+ 0.347957980000 0.00
+ 0.347958000000 4.50
+ 0.349999980000 4.50
+ 0.350000000000 0.00
+ 0.350000020000 0.00
+ 0.370000000000 0.00
+ )
Vdriverow7 row7cmd 0 PWL(
+ 0.000000000000 4.50
+ 0.001840980000 4.50
+ 0.001841000000 0.00
+ 0.001846980000 0.00
+ 0.001847000000 4.50
+ 0.003888980000 4.50
+ 0.003889000000 0.00
+ 0.003894980000 0.00
+ 0.003895000000 4.50
+ 0.005934480000 4.50
+ 0.005934500000 0.00
+ 0.010047980000 0.00
+ 0.010048000000 4.50
+ 0.012078480000 4.50
+ 0.012078500000 0.00
+ 0.012084480000 0.00
+ 0.012084500000 4.50
+ 0.014126980000 4.50
+ 0.014127000000 0.00
+ 0.014132980000 0.00
+ 0.014133000000 4.50
+ 0.016175480000 4.50
+ 0.016175500000 0.00
+ 0.016181480000 0.00
+ 0.016181500000 4.50
+ 0.018227480000 4.50
+ 0.018227500000 0.00
+ 0.018233480000 0.00
+ 0.018233500000 4.50
+ 0.020271480000 4.50
+ 0.020271500000 0.00
+ 0.020277480000 0.00
+ 0.020277500000 4.50
+ 0.022318480000 4.50
+ 0.022318500000 0.00
+ 0.026431480000 0.00
+ 0.026431500000 4.50
+ 0.028462480000 4.50
+ 0.028462500000 0.00
+ 0.028468480000 0.00
+ 0.028468500000 4.50
+ 0.030511480000 4.50
+ 0.030511500000 0.00
+ 0.030517480000 0.00
+ 0.030517500000 4.50
+ 0.032559480000 4.50
+ 0.032559500000 0.00
+ 0.032565480000 0.00
+ 0.032565500000 4.50
+ 0.034610980000 4.50
+ 0.034611000000 0.00
+ 0.034616980000 0.00
+ 0.034617000000 4.50
+ 0.036654980000 4.50
+ 0.036655000000 0.00
+ 0.036660980000 0.00
+ 0.036661000000 4.50
+ 0.038703980000 4.50
+ 0.038704000000 0.00
+ 0.042818980000 0.00
+ 0.042819000000 4.50
+ 0.044846480000 4.50
+ 0.044846500000 0.00
+ 0.044852480000 0.00
+ 0.044852500000 4.50
+ 0.046895480000 4.50
+ 0.046895500000 0.00
+ 0.046901480000 0.00
+ 0.046901500000 4.50
+ 0.048943480000 4.50
+ 0.048943500000 0.00
+ 0.048949480000 0.00
+ 0.048949500000 4.50
+ 0.050995980000 4.50
+ 0.050996000000 0.00
+ 0.051001980000 0.00
+ 0.051002000000 4.50
+ 0.053039980000 4.50
+ 0.053040000000 0.00
+ 0.053045980000 0.00
+ 0.053046000000 4.50
+ 0.055088480000 4.50
+ 0.055088500000 0.00
+ 0.059202980000 0.00
+ 0.059203000000 4.50
+ 0.061233980000 4.50
+ 0.061234000000 0.00
+ 0.061239980000 0.00
+ 0.061240000000 4.50
+ 0.063279480000 4.50
+ 0.063279500000 0.00
+ 0.063285480000 0.00
+ 0.063285500000 4.50
+ 0.065326480000 4.50
+ 0.065326500000 0.00
+ 0.065332480000 0.00
+ 0.065332500000 4.50
+ 0.067375480000 4.50
+ 0.067375500000 0.00
+ 0.067381480000 0.00
+ 0.067381500000 4.50
+ 0.069422980000 4.50
+ 0.069423000000 0.00
+ 0.069428980000 0.00
+ 0.069429000000 4.50
+ 0.071471980000 4.50
+ 0.071472000000 0.00
+ 0.075579980000 0.00
+ 0.075580000000 4.50
+ 0.077614480000 4.50
+ 0.077614500000 0.00
+ 0.077620480000 0.00
+ 0.077620500000 4.50
+ 0.079663980000 4.50
+ 0.079664000000 0.00
+ 0.079669980000 0.00
+ 0.079670000000 4.50
+ 0.081710480000 4.50
+ 0.081710500000 0.00
+ 0.081716480000 0.00
+ 0.081716500000 4.50
+ 0.083759980000 4.50
+ 0.083760000000 0.00
+ 0.083765980000 0.00
+ 0.083766000000 4.50
+ 0.085806480000 4.50
+ 0.085806500000 0.00
+ 0.085812480000 0.00
+ 0.085812500000 4.50
+ 0.087854980000 4.50
+ 0.087855000000 0.00
+ 0.091962480000 0.00
+ 0.091962500000 4.50
+ 0.093998980000 4.50
+ 0.093999000000 0.00
+ 0.094004980000 0.00
+ 0.094005000000 4.50
+ 0.096051480000 4.50
+ 0.096051500000 0.00
+ 0.096057480000 0.00
+ 0.096057500000 4.50
+ 0.098096980000 4.50
+ 0.098097000000 0.00
+ 0.098102980000 0.00
+ 0.098103000000 4.50
+ 0.100143980000 4.50
+ 0.100144000000 0.00
+ 0.100149980000 0.00
+ 0.100150000000 4.50
+ 0.102190480000 4.50
+ 0.102190500000 0.00
+ 0.102196480000 0.00
+ 0.102196500000 4.50
+ 0.104240480000 4.50
+ 0.104240500000 0.00
+ 0.106310480000 0.00
+ 0.106310500000 4.50
+ 0.108343480000 4.50
+ 0.108343500000 0.00
+ 0.108349480000 0.00
+ 0.108349500000 4.50
+ 0.110383980000 4.50
+ 0.110384000000 0.00
+ 0.110389980000 0.00
+ 0.110390000000 4.50
+ 0.112430980000 4.50
+ 0.112431000000 0.00
+ 0.112436980000 0.00
+ 0.112437000000 4.50
+ 0.114479480000 4.50
+ 0.114479500000 0.00
+ 0.114485480000 0.00
+ 0.114485500000 4.50
+ 0.116526480000 4.50
+ 0.116526500000 0.00
+ 0.116532480000 0.00
+ 0.116532500000 4.50
+ 0.118574980000 4.50
+ 0.118575000000 0.00
+ 0.118580980000 0.00
+ 0.118581000000 4.50
+ 0.120623980000 4.50
+ 0.120624000000 0.00
+ 0.122692980000 0.00
+ 0.122693000000 4.50
+ 0.124724980000 4.50
+ 0.124725000000 0.00
+ 0.124730980000 0.00
+ 0.124731000000 4.50
+ 0.126771980000 4.50
+ 0.126772000000 0.00
+ 0.126777980000 0.00
+ 0.126778000000 4.50
+ 0.128815980000 4.50
+ 0.128816000000 0.00
+ 0.128821980000 0.00
+ 0.128822000000 4.50
+ 0.130863480000 4.50
+ 0.130863500000 0.00
+ 0.130869480000 0.00
+ 0.130869500000 4.50
+ 0.132911480000 4.50
+ 0.132911500000 0.00
+ 0.132917480000 0.00
+ 0.132917500000 4.50
+ 0.134963480000 4.50
+ 0.134963500000 0.00
+ 0.134969480000 0.00
+ 0.134969500000 4.50
+ 0.137006480000 4.50
+ 0.137006500000 0.00
+ 0.139132980000 0.00
+ 0.139133000000 4.50
+ 0.141109980000 4.50
+ 0.141110000000 0.00
+ 0.141115980000 0.00
+ 0.141116000000 4.50
+ 0.143155480000 4.50
+ 0.143155500000 0.00
+ 0.143161480000 0.00
+ 0.143161500000 4.50
+ 0.145198480000 4.50
+ 0.145198500000 0.00
+ 0.145204480000 0.00
+ 0.145204500000 4.50
+ 0.147247480000 4.50
+ 0.147247500000 0.00
+ 0.147253480000 0.00
+ 0.147253500000 4.50
+ 0.149294480000 4.50
+ 0.149294500000 0.00
+ 0.149300480000 0.00
+ 0.149300500000 4.50
+ 0.151349980000 4.50
+ 0.151350000000 0.00
+ 0.151355980000 0.00
+ 0.151356000000 4.50
+ 0.153392980000 4.50
+ 0.153393000000 0.00
+ 0.155461980000 0.00
+ 0.155462000000 4.50
+ 0.157492980000 4.50
+ 0.157493000000 0.00
+ 0.157498980000 0.00
+ 0.157499000000 4.50
+ 0.159539480000 4.50
+ 0.159539500000 0.00
+ 0.159545480000 0.00
+ 0.159545500000 4.50
+ 0.161582480000 4.50
+ 0.161582500000 0.00
+ 0.161588480000 0.00
+ 0.161588500000 4.50
+ 0.163630480000 4.50
+ 0.163630500000 0.00
+ 0.163636480000 0.00
+ 0.163636500000 4.50
+ 0.165682980000 4.50
+ 0.165683000000 0.00
+ 0.165688980000 0.00
+ 0.165689000000 4.50
+ 0.167731480000 4.50
+ 0.167731500000 0.00
+ 0.167737480000 0.00
+ 0.167737500000 4.50
+ 0.169775480000 4.50
+ 0.169775500000 0.00
+ 0.171845480000 0.00
+ 0.171845500000 4.50
+ 0.173878980000 4.50
+ 0.173879000000 0.00
+ 0.173884980000 0.00
+ 0.173885000000 4.50
+ 0.175923980000 4.50
+ 0.175924000000 0.00
+ 0.175929980000 0.00
+ 0.175930000000 4.50
+ 0.177970980000 4.50
+ 0.177971000000 0.00
+ 0.177976980000 0.00
+ 0.177977000000 4.50
+ 0.180014480000 4.50
+ 0.180014500000 0.00
+ 0.180020480000 0.00
+ 0.180020500000 4.50
+ 0.182063480000 4.50
+ 0.182063500000 0.00
+ 0.182069480000 0.00
+ 0.182069500000 4.50
+ 0.184114980000 4.50
+ 0.184115000000 0.00
+ 0.184120980000 0.00
+ 0.184121000000 4.50
+ 0.186158980000 4.50
+ 0.186159000000 0.00
+ 0.188229480000 0.00
+ 0.188229500000 4.50
+ 0.190260480000 4.50
+ 0.190260500000 0.00
+ 0.190266480000 0.00
+ 0.190266500000 4.50
+ 0.192306480000 4.50
+ 0.192306500000 0.00
+ 0.192312480000 0.00
+ 0.192312500000 4.50
+ 0.194350980000 4.50
+ 0.194351000000 0.00
+ 0.194356980000 0.00
+ 0.194357000000 4.50
+ 0.196398980000 4.50
+ 0.196399000000 0.00
+ 0.196404980000 0.00
+ 0.196405000000 4.50
+ 0.198446480000 4.50
+ 0.198446500000 0.00
+ 0.198452480000 0.00
+ 0.198452500000 4.50
+ 0.200494480000 4.50
+ 0.200494500000 0.00
+ 0.200500480000 0.00
+ 0.200500500000 4.50
+ 0.202543480000 4.50
+ 0.202543500000 0.00
+ 0.204669480000 0.00
+ 0.204669500000 4.50
+ 0.206644980000 4.50
+ 0.206645000000 0.00
+ 0.206650980000 0.00
+ 0.206651000000 4.50
+ 0.208686480000 4.50
+ 0.208686500000 0.00
+ 0.208692480000 0.00
+ 0.208692500000 4.50
+ 0.210735480000 4.50
+ 0.210735500000 0.00
+ 0.210741480000 0.00
+ 0.210741500000 4.50
+ 0.212782980000 4.50
+ 0.212783000000 0.00
+ 0.212788980000 0.00
+ 0.212789000000 4.50
+ 0.214830980000 4.50
+ 0.214831000000 0.00
+ 0.214836980000 0.00
+ 0.214837000000 4.50
+ 0.216878480000 4.50
+ 0.216878500000 0.00
+ 0.216884480000 0.00
+ 0.216884500000 4.50
+ 0.218927980000 4.50
+ 0.218928000000 0.00
+ 0.220998480000 0.00
+ 0.220998500000 4.50
+ 0.223028480000 4.50
+ 0.223028500000 0.00
+ 0.223034480000 0.00
+ 0.223034500000 4.50
+ 0.225070480000 4.50
+ 0.225070500000 0.00
+ 0.225076480000 0.00
+ 0.225076500000 4.50
+ 0.227118980000 4.50
+ 0.227119000000 0.00
+ 0.227124980000 0.00
+ 0.227125000000 4.50
+ 0.229166980000 4.50
+ 0.229167000000 0.00
+ 0.229172980000 0.00
+ 0.229173000000 4.50
+ 0.231214480000 4.50
+ 0.231214500000 0.00
+ 0.231220480000 0.00
+ 0.231220500000 4.50
+ 0.233263980000 4.50
+ 0.233264000000 0.00
+ 0.233269980000 0.00
+ 0.233270000000 4.50
+ 0.235310480000 4.50
+ 0.235310500000 0.00
+ 0.237380980000 0.00
+ 0.237381000000 4.50
+ 0.239413480000 4.50
+ 0.239413500000 0.00
+ 0.239419480000 0.00
+ 0.239419500000 4.50
+ 0.241454480000 4.50
+ 0.241454500000 0.00
+ 0.241460480000 0.00
+ 0.241460500000 4.50
+ 0.243503980000 4.50
+ 0.243504000000 0.00
+ 0.243509980000 0.00
+ 0.243510000000 4.50
+ 0.245550980000 4.50
+ 0.245551000000 0.00
+ 0.245556980000 0.00
+ 0.245557000000 4.50
+ 0.247599480000 4.50
+ 0.247599500000 0.00
+ 0.247605480000 0.00
+ 0.247605500000 4.50
+ 0.249646480000 4.50
+ 0.249646500000 0.00
+ 0.249652480000 0.00
+ 0.249652500000 4.50
+ 0.251701480000 4.50
+ 0.251701500000 0.00
+ 0.253767980000 0.00
+ 0.253768000000 4.50
+ 0.255796480000 4.50
+ 0.255796500000 0.00
+ 0.255802480000 0.00
+ 0.255802500000 4.50
+ 0.257838980000 4.50
+ 0.257839000000 0.00
+ 0.257844980000 0.00
+ 0.257845000000 4.50
+ 0.259891480000 4.50
+ 0.259891500000 0.00
+ 0.259897480000 0.00
+ 0.259897500000 4.50
+ 0.261935980000 4.50
+ 0.261936000000 0.00
+ 0.261941980000 0.00
+ 0.261942000000 4.50
+ 0.263982480000 4.50
+ 0.263982500000 0.00
+ 0.263988480000 0.00
+ 0.263988500000 4.50
+ 0.266031480000 4.50
+ 0.266031500000 0.00
+ 0.266037480000 0.00
+ 0.266037500000 4.50
+ 0.268083480000 4.50
+ 0.268083500000 0.00
+ 0.270204980000 0.00
+ 0.270205000000 4.50
+ 0.272181980000 4.50
+ 0.272182000000 0.00
+ 0.272187980000 0.00
+ 0.272188000000 4.50
+ 0.274222980000 4.50
+ 0.274223000000 0.00
+ 0.274228980000 0.00
+ 0.274229000000 4.50
+ 0.276275980000 4.50
+ 0.276276000000 0.00
+ 0.276281980000 0.00
+ 0.276282000000 4.50
+ 0.278321480000 4.50
+ 0.278321500000 0.00
+ 0.278327480000 0.00
+ 0.278327500000 4.50
+ 0.280367480000 4.50
+ 0.280367500000 0.00
+ 0.280373480000 0.00
+ 0.280373500000 4.50
+ 0.282415980000 4.50
+ 0.282416000000 0.00
+ 0.282421980000 0.00
+ 0.282422000000 4.50
+ 0.284468480000 4.50
+ 0.284468500000 0.00
+ 0.286533980000 0.00
+ 0.286534000000 4.50
+ 0.288564980000 4.50
+ 0.288565000000 0.00
+ 0.288570980000 0.00
+ 0.288571000000 4.50
+ 0.290607980000 4.50
+ 0.290608000000 0.00
+ 0.290613980000 0.00
+ 0.290614000000 4.50
+ 0.292659480000 4.50
+ 0.292659500000 0.00
+ 0.292665480000 0.00
+ 0.292665500000 4.50
+ 0.294702980000 4.50
+ 0.294703000000 0.00
+ 0.294708980000 0.00
+ 0.294709000000 4.50
+ 0.296752980000 4.50
+ 0.296753000000 0.00
+ 0.296758980000 0.00
+ 0.296759000000 4.50
+ 0.298798980000 4.50
+ 0.298799000000 0.00
+ 0.298804980000 0.00
+ 0.298805000000 4.50
+ 0.300851980000 4.50
+ 0.300852000000 0.00
+ 0.302916980000 0.00
+ 0.302917000000 4.50
+ 0.304951480000 4.50
+ 0.304951500000 0.00
+ 0.304957480000 0.00
+ 0.304957500000 4.50
+ 0.306992480000 4.50
+ 0.306992500000 0.00
+ 0.306998480000 0.00
+ 0.306998500000 4.50
+ 0.309038980000 4.50
+ 0.309039000000 0.00
+ 0.309044980000 0.00
+ 0.309045000000 4.50
+ 0.311087980000 4.50
+ 0.311088000000 0.00
+ 0.311093980000 0.00
+ 0.311094000000 4.50
+ 0.313134980000 4.50
+ 0.313135000000 0.00
+ 0.313140980000 0.00
+ 0.313141000000 4.50
+ 0.315182480000 4.50
+ 0.315182500000 0.00
+ 0.315188480000 0.00
+ 0.315188500000 4.50
+ 0.317230480000 4.50
+ 0.317230500000 0.00
+ 0.319301980000 0.00
+ 0.319302000000 4.50
+ 0.321333480000 4.50
+ 0.321333500000 0.00
+ 0.321339480000 0.00
+ 0.321339500000 4.50
+ 0.323375980000 4.50
+ 0.323376000000 0.00
+ 0.323381980000 0.00
+ 0.323382000000 4.50
+ 0.325423480000 4.50
+ 0.325423500000 0.00
+ 0.325429480000 0.00
+ 0.325429500000 4.50
+ 0.327470980000 4.50
+ 0.327471000000 0.00
+ 0.327476980000 0.00
+ 0.327477000000 4.50
+ 0.329519980000 4.50
+ 0.329520000000 0.00
+ 0.329525980000 0.00
+ 0.329526000000 4.50
+ 0.331567480000 4.50
+ 0.331567500000 0.00
+ 0.331573480000 0.00
+ 0.331573500000 4.50
+ 0.333614980000 4.50
+ 0.333615000000 0.00
+ 0.337726480000 0.00
+ 0.337726500000 4.50
+ 0.339759480000 4.50
+ 0.339759500000 0.00
+ 0.339765480000 0.00
+ 0.339765500000 4.50
+ 0.341806480000 4.50
+ 0.341806500000 0.00
+ 0.341812480000 0.00
+ 0.341812500000 4.50
+ 0.343856980000 4.50
+ 0.343857000000 0.00
+ 0.343862980000 0.00
+ 0.343863000000 4.50
+ 0.345902980000 4.50
+ 0.345903000000 0.00
+ 0.345908980000 0.00
+ 0.345909000000 4.50
+ 0.347951980000 4.50
+ 0.347952000000 0.00
+ 0.347957980000 0.00
+ 0.347958000000 4.50
+ 0.349999980000 4.50
+ 0.350000000000 0.00
+ 0.350000020000 0.00
+ 0.370000000000 0.00
+ )
Vdrivecol0 col0cmd 0 PWL(
+ 0.000000000000 0.00
+ 0.010045480000 0.00
+ 0.010045500000 4.50
+ 0.012081980000 4.50
+ 0.012082000000 0.00
+ 0.026428980000 0.00
+ 0.026429000000 4.50
+ 0.028465980000 4.50
+ 0.028466000000 0.00
+ 0.042816480000 0.00
+ 0.042816500000 4.50
+ 0.044849980000 4.50
+ 0.044850000000 0.00
+ 0.059200480000 0.00
+ 0.059200500000 4.50
+ 0.061237480000 4.50
+ 0.061237500000 0.00
+ 0.075577480000 0.00
+ 0.075577500000 4.50
+ 0.077617980000 4.50
+ 0.077618000000 0.00
+ 0.091959980000 0.00
+ 0.091960000000 4.50
+ 0.094002480000 4.50
+ 0.094002500000 0.00
+ 0.108346980000 0.00
+ 0.108347000000 4.50
+ 0.110387480000 4.50
+ 0.110387500000 0.00
+ 0.124728480000 0.00
+ 0.124728500000 4.50
+ 0.126775480000 4.50
+ 0.126775500000 0.00
+ 0.141113480000 0.00
+ 0.141113500000 4.50
+ 0.143158980000 4.50
+ 0.143159000000 0.00
+ 0.157496480000 0.00
+ 0.157496500000 4.50
+ 0.159542980000 4.50
+ 0.159543000000 0.00
+ 0.173882480000 0.00
+ 0.173882500000 4.50
+ 0.175927480000 4.50
+ 0.175927500000 0.00
+ 0.190263980000 0.00
+ 0.190264000000 4.50
+ 0.192309980000 4.50
+ 0.192310000000 0.00
+ 0.206648480000 0.00
+ 0.206648500000 4.50
+ 0.208689980000 4.50
+ 0.208690000000 0.00
+ 0.223031980000 0.00
+ 0.223032000000 4.50
+ 0.225073980000 4.50
+ 0.225074000000 0.00
+ 0.239416980000 0.00
+ 0.239417000000 4.50
+ 0.241457980000 4.50
+ 0.241458000000 0.00
+ 0.255799980000 0.00
+ 0.255800000000 4.50
+ 0.257842480000 4.50
+ 0.257842500000 0.00
+ 0.272185480000 0.00
+ 0.272185500000 4.50
+ 0.274226480000 4.50
+ 0.274226500000 0.00
+ 0.288568480000 0.00
+ 0.288568500000 4.50
+ 0.290611480000 4.50
+ 0.290611500000 0.00
+ 0.304954980000 0.00
+ 0.304955000000 4.50
+ 0.306995980000 4.50
+ 0.306996000000 0.00
+ 0.321336980000 0.00
+ 0.321337000000 4.50
+ 0.323379480000 4.50
+ 0.323379500000 0.00
+ 0.337723980000 0.00
+ 0.337724000000 4.50
+ 0.339762980000 4.50
+ 0.339763000000 0.00
+ 0.350000000000 0.00
+ 0.350000020000 0.00
+ 0.370000000000 0.00
+ )
Vdrivecol1 col1cmd 0 PWL(
+ 0.000000000000 0.00
+ 0.012081980000 0.00
+ 0.012082000000 4.50
+ 0.014130480000 4.50
+ 0.014130500000 0.00
+ 0.028465980000 0.00
+ 0.028466000000 4.50
+ 0.030514980000 4.50
+ 0.030515000000 0.00
+ 0.044849980000 0.00
+ 0.044850000000 4.50
+ 0.046898980000 4.50
+ 0.046899000000 0.00
+ 0.061237480000 0.00
+ 0.061237500000 4.50
+ 0.063282980000 4.50
+ 0.063283000000 0.00
+ 0.077617980000 0.00
+ 0.077618000000 4.50
+ 0.079667480000 4.50
+ 0.079667500000 0.00
+ 0.094002480000 0.00
+ 0.094002500000 4.50
+ 0.096054980000 4.50
+ 0.096055000000 0.00
+ 0.110387480000 0.00
+ 0.110387500000 4.50
+ 0.112434480000 4.50
+ 0.112434500000 0.00
+ 0.126775480000 0.00
+ 0.126775500000 4.50
+ 0.128819480000 4.50
+ 0.128819500000 0.00
+ 0.143158980000 0.00
+ 0.143159000000 4.50
+ 0.145201980000 4.50
+ 0.145202000000 0.00
+ 0.159542980000 0.00
+ 0.159543000000 4.50
+ 0.161585980000 4.50
+ 0.161586000000 0.00
+ 0.175927480000 0.00
+ 0.175927500000 4.50
+ 0.177974480000 4.50
+ 0.177974500000 0.00
+ 0.192309980000 0.00
+ 0.192310000000 4.50
+ 0.194354480000 4.50
+ 0.194354500000 0.00
+ 0.208689980000 0.00
+ 0.208690000000 4.50
+ 0.210738980000 4.50
+ 0.210739000000 0.00
+ 0.225073980000 0.00
+ 0.225074000000 4.50
+ 0.227122480000 4.50
+ 0.227122500000 0.00
+ 0.241457980000 0.00
+ 0.241458000000 4.50
+ 0.243507480000 4.50
+ 0.243507500000 0.00
+ 0.257842480000 0.00
+ 0.257842500000 4.50
+ 0.259894980000 4.50
+ 0.259895000000 0.00
+ 0.274226480000 0.00
+ 0.274226500000 4.50
+ 0.276279480000 4.50
+ 0.276279500000 0.00
+ 0.290611480000 0.00
+ 0.290611500000 4.50
+ 0.292662980000 4.50
+ 0.292663000000 0.00
+ 0.306995980000 0.00
+ 0.306996000000 4.50
+ 0.309042480000 4.50
+ 0.309042500000 0.00
+ 0.323379480000 0.00
+ 0.323379500000 4.50
+ 0.325426980000 4.50
+ 0.325427000000 0.00
+ 0.339762980000 0.00
+ 0.339763000000 4.50
+ 0.341809980000 4.50
+ 0.341810000000 0.00
+ 0.350000000000 0.00
+ 0.350000020000 0.00
+ 0.370000000000 0.00
+ )
Vdrivecol2 col2cmd 0 PWL(
+ 0.000000000000 0.00
+ 0.014130480000 0.00
+ 0.014130500000 4.50
+ 0.016178980000 4.50
+ 0.016179000000 0.00
+ 0.030514980000 0.00
+ 0.030515000000 4.50
+ 0.032562980000 4.50
+ 0.032563000000 0.00
+ 0.046898980000 0.00
+ 0.046899000000 4.50
+ 0.048946980000 4.50
+ 0.048947000000 0.00
+ 0.063282980000 0.00
+ 0.063283000000 4.50
+ 0.065329980000 4.50
+ 0.065330000000 0.00
+ 0.079667480000 0.00
+ 0.079667500000 4.50
+ 0.081713980000 4.50
+ 0.081714000000 0.00
+ 0.096054980000 0.00
+ 0.096055000000 4.50
+ 0.098100480000 4.50
+ 0.098100500000 0.00
+ 0.112434480000 0.00
+ 0.112434500000 4.50
+ 0.114482980000 4.50
+ 0.114483000000 0.00
+ 0.128819480000 0.00
+ 0.128819500000 4.50
+ 0.130866980000 4.50
+ 0.130867000000 0.00
+ 0.145201980000 0.00
+ 0.145202000000 4.50
+ 0.147250980000 4.50
+ 0.147251000000 0.00
+ 0.161585980000 0.00
+ 0.161586000000 4.50
+ 0.163633980000 4.50
+ 0.163634000000 0.00
+ 0.177974480000 0.00
+ 0.177974500000 4.50
+ 0.180017980000 4.50
+ 0.180018000000 0.00
+ 0.194354480000 0.00
+ 0.194354500000 4.50
+ 0.196402480000 4.50
+ 0.196402500000 0.00
+ 0.210738980000 0.00
+ 0.210739000000 4.50
+ 0.212786480000 4.50
+ 0.212786500000 0.00
+ 0.227122480000 0.00
+ 0.227122500000 4.50
+ 0.229170480000 4.50
+ 0.229170500000 0.00
+ 0.243507480000 0.00
+ 0.243507500000 4.50
+ 0.245554480000 4.50
+ 0.245554500000 0.00
+ 0.259894980000 0.00
+ 0.259895000000 4.50
+ 0.261939480000 4.50
+ 0.261939500000 0.00
+ 0.276279480000 0.00
+ 0.276279500000 4.50
+ 0.278324980000 4.50
+ 0.278325000000 0.00
+ 0.292662980000 0.00
+ 0.292663000000 4.50
+ 0.294706480000 4.50
+ 0.294706500000 0.00
+ 0.309042480000 0.00
+ 0.309042500000 4.50
+ 0.311091480000 4.50
+ 0.311091500000 0.00
+ 0.325426980000 0.00
+ 0.325427000000 4.50
+ 0.327474480000 4.50
+ 0.327474500000 0.00
+ 0.341809980000 0.00
+ 0.341810000000 4.50
+ 0.343860480000 4.50
+ 0.343860500000 0.00
+ 0.350000000000 0.00
+ 0.350000020000 0.00
+ 0.370000000000 0.00
+ )
Vdrivecol3 col3cmd 0 PWL(
+ 0.000000000000 4.50
+ 0.001844480000 4.50
+ 0.001844500000 0.00
+ 0.016178980000 0.00
+ 0.016179000000 4.50
+ 0.018230980000 4.50
+ 0.018231000000 0.00
+ 0.032562980000 0.00
+ 0.032563000000 4.50
+ 0.034614480000 4.50
+ 0.034614500000 0.00
+ 0.048946980000 0.00
+ 0.048947000000 4.50
+ 0.050999480000 4.50
+ 0.050999500000 0.00
+ 0.065329980000 0.00
+ 0.065330000000 4.50
+ 0.067378980000 4.50
+ 0.067379000000 0.00
+ 0.081713980000 0.00
+ 0.081714000000 4.50
+ 0.083763480000 4.50
+ 0.083763500000 0.00
+ 0.098100480000 0.00
+ 0.098100500000 4.50
+ 0.100147480000 4.50
+ 0.100147500000 0.00
+ 0.114482980000 0.00
+ 0.114483000000 4.50
+ 0.116529980000 4.50
+ 0.116530000000 0.00
+ 0.130866980000 0.00
+ 0.130867000000 4.50
+ 0.132914980000 4.50
+ 0.132915000000 0.00
+ 0.147250980000 0.00
+ 0.147251000000 4.50
+ 0.149297980000 4.50
+ 0.149298000000 0.00
+ 0.163633980000 0.00
+ 0.163634000000 4.50
+ 0.165686480000 4.50
+ 0.165686500000 0.00
+ 0.180017980000 0.00
+ 0.180018000000 4.50
+ 0.182066980000 4.50
+ 0.182067000000 0.00
+ 0.196402480000 0.00
+ 0.196402500000 4.50
+ 0.198449980000 4.50
+ 0.198450000000 0.00
+ 0.212786480000 0.00
+ 0.212786500000 4.50
+ 0.214834480000 4.50
+ 0.214834500000 0.00
+ 0.229170480000 0.00
+ 0.229170500000 4.50
+ 0.231217980000 4.50
+ 0.231218000000 0.00
+ 0.245554480000 0.00
+ 0.245554500000 4.50
+ 0.247602980000 4.50
+ 0.247603000000 0.00
+ 0.261939480000 0.00
+ 0.261939500000 4.50
+ 0.263985980000 4.50
+ 0.263986000000 0.00
+ 0.278324980000 0.00
+ 0.278325000000 4.50
+ 0.280370980000 4.50
+ 0.280371000000 0.00
+ 0.294706480000 0.00
+ 0.294706500000 4.50
+ 0.296756480000 4.50
+ 0.296756500000 0.00
+ 0.311091480000 0.00
+ 0.311091500000 4.50
+ 0.313138480000 4.50
+ 0.313138500000 0.00
+ 0.327474480000 0.00
+ 0.327474500000 4.50
+ 0.329523480000 4.50
+ 0.329523500000 0.00
+ 0.343860480000 0.00
+ 0.343860500000 4.50
+ 0.345906480000 4.50
+ 0.345906500000 0.00
+ 0.350000000000 0.00
+ 0.350000020000 0.00
+ 0.370000000000 0.00
+ )
Vdrivecol4 col4cmd 0 PWL(
+ 0.000000000000 0.00
+ 0.001844480000 0.00
+ 0.001844500000 4.50
+ 0.003892480000 4.50
+ 0.003892500000 0.00
+ 0.018230980000 0.00
+ 0.018231000000 4.50
+ 0.020274980000 4.50
+ 0.020275000000 0.00
+ 0.034614480000 0.00
+ 0.034614500000 4.50
+ 0.036658480000 4.50
+ 0.036658500000 0.00
+ 0.050999480000 0.00
+ 0.050999500000 4.50
+ 0.053043480000 4.50
+ 0.053043500000 0.00
+ 0.067378980000 0.00
+ 0.067379000000 4.50
+ 0.069426480000 4.50
+ 0.069426500000 0.00
+ 0.083763480000 0.00
+ 0.083763500000 4.50
+ 0.085809980000 4.50
+ 0.085810000000 0.00
+ 0.100147480000 0.00
+ 0.100147500000 4.50
+ 0.102193980000 4.50
+ 0.102194000000 0.00
+ 0.116529980000 0.00
+ 0.116530000000 4.50
+ 0.118578480000 4.50
+ 0.118578500000 0.00
+ 0.132914980000 0.00
+ 0.132915000000 4.50
+ 0.134966980000 4.50
+ 0.134967000000 0.00
+ 0.149297980000 0.00
+ 0.149298000000 4.50
+ 0.151353480000 4.50
+ 0.151353500000 0.00
+ 0.165686480000 0.00
+ 0.165686500000 4.50
+ 0.167734980000 4.50
+ 0.167735000000 0.00
+ 0.182066980000 0.00
+ 0.182067000000 4.50
+ 0.184118480000 4.50
+ 0.184118500000 0.00
+ 0.198449980000 0.00
+ 0.198450000000 4.50
+ 0.200497980000 4.50
+ 0.200498000000 0.00
+ 0.214834480000 0.00
+ 0.214834500000 4.50
+ 0.216881980000 4.50
+ 0.216882000000 0.00
+ 0.231217980000 0.00
+ 0.231218000000 4.50
+ 0.233267480000 4.50
+ 0.233267500000 0.00
+ 0.247602980000 0.00
+ 0.247603000000 4.50
+ 0.249649980000 4.50
+ 0.249650000000 0.00
+ 0.263985980000 0.00
+ 0.263986000000 4.50
+ 0.266034980000 4.50
+ 0.266035000000 0.00
+ 0.280370980000 0.00
+ 0.280371000000 4.50
+ 0.282419480000 4.50
+ 0.282419500000 0.00
+ 0.296756480000 0.00
+ 0.296756500000 4.50
+ 0.298802480000 4.50
+ 0.298802500000 0.00
+ 0.313138480000 0.00
+ 0.313138500000 4.50
+ 0.315185980000 4.50
+ 0.315186000000 0.00
+ 0.329523480000 0.00
+ 0.329523500000 4.50
+ 0.331570980000 4.50
+ 0.331571000000 0.00
+ 0.345906480000 0.00
+ 0.345906500000 4.50
+ 0.347955480000 4.50
+ 0.347955500000 0.00
+ 0.350000000000 0.00
+ 0.350000020000 0.00
+ 0.370000000000 0.00
+ )
Vdrivecol5 col5cmd 0 PWL(
+ 0.000000000000 0.00
+ 0.003892480000 0.00
+ 0.003892500000 4.50
+ 0.005937980000 4.50
+ 0.005938000000 0.00
+ 0.020274980000 0.00
+ 0.020275000000 4.50
+ 0.022321980000 4.50
+ 0.022322000000 0.00
+ 0.036658480000 0.00
+ 0.036658500000 4.50
+ 0.038707480000 4.50
+ 0.038707500000 0.00
+ 0.053043480000 0.00
+ 0.053043500000 4.50
+ 0.055091980000 4.50
+ 0.055092000000 0.00
+ 0.069426480000 0.00
+ 0.069426500000 4.50
+ 0.071475480000 4.50
+ 0.071475500000 0.00
+ 0.085809980000 0.00
+ 0.085810000000 4.50
+ 0.087858480000 4.50
+ 0.087858500000 0.00
+ 0.102193980000 0.00
+ 0.102194000000 4.50
+ 0.104243980000 4.50
+ 0.104244000000 0.00
+ 0.118578480000 0.00
+ 0.118578500000 4.50
+ 0.120627480000 4.50
+ 0.120627500000 0.00
+ 0.134966980000 0.00
+ 0.134967000000 4.50
+ 0.137009980000 4.50
+ 0.137010000000 0.00
+ 0.151353480000 0.00
+ 0.151353500000 4.50
+ 0.153396480000 4.50
+ 0.153396500000 0.00
+ 0.167734980000 0.00
+ 0.167735000000 4.50
+ 0.169778980000 4.50
+ 0.169779000000 0.00
+ 0.184118480000 0.00
+ 0.184118500000 4.50
+ 0.186162480000 4.50
+ 0.186162500000 0.00
+ 0.200497980000 0.00
+ 0.200498000000 4.50
+ 0.202546980000 4.50
+ 0.202547000000 0.00
+ 0.216881980000 0.00
+ 0.216882000000 4.50
+ 0.218931480000 4.50
+ 0.218931500000 0.00
+ 0.233267480000 0.00
+ 0.233267500000 4.50
+ 0.235313980000 4.50
+ 0.235314000000 0.00
+ 0.249649980000 0.00
+ 0.249650000000 4.50
+ 0.251704980000 4.50
+ 0.251705000000 0.00
+ 0.266034980000 0.00
+ 0.266035000000 4.50
+ 0.268086980000 4.50
+ 0.268087000000 0.00
+ 0.282419480000 0.00
+ 0.282419500000 4.50
+ 0.284471980000 4.50
+ 0.284472000000 0.00
+ 0.298802480000 0.00
+ 0.298802500000 4.50
+ 0.300855480000 4.50
+ 0.300855500000 0.00
+ 0.315185980000 0.00
+ 0.315186000000 4.50
+ 0.317233980000 4.50
+ 0.317234000000 0.00
+ 0.331570980000 0.00
+ 0.331571000000 4.50
+ 0.333618480000 4.50
+ 0.333618500000 0.00
+ 0.347955480000 0.00
+ 0.347955500000 4.50
+ 0.350000000000 4.50
+ 0.350000020000 0.00
+ 0.370000000000 0.00
+ )
Vdrivecol6 col6cmd 0 PWL(
+ 0.000000000000 0.00
+ 0.005937980000 0.00
+ 0.005938000000 4.50
+ 0.008058480000 4.50
+ 0.008058500000 0.00
+ 0.022321980000 0.00
+ 0.022322000000 4.50
+ 0.024386980000 4.50
+ 0.024387000000 0.00
+ 0.038707480000 0.00
+ 0.038707500000 4.50
+ 0.040770480000 4.50
+ 0.040770500000 0.00
+ 0.055091980000 0.00
+ 0.055092000000 4.50
+ 0.057155480000 4.50
+ 0.057155500000 0.00
+ 0.071475480000 0.00
+ 0.071475500000 4.50
+ 0.073594480000 4.50
+ 0.073594500000 0.00
+ 0.087858480000 0.00
+ 0.087858500000 4.50
+ 0.089923480000 4.50
+ 0.089923500000 0.00
+ 0.104243980000 0.00
+ 0.104244000000 4.50
+ 0.106307980000 4.50
+ 0.106308000000 0.00
+ 0.120627480000 0.00
+ 0.120627500000 4.50
+ 0.122690480000 4.50
+ 0.122690500000 0.00
+ 0.137009980000 0.00
+ 0.137010000000 4.50
+ 0.139130480000 4.50
+ 0.139130500000 0.00
+ 0.153396480000 0.00
+ 0.153396500000 4.50
+ 0.155459480000 4.50
+ 0.155459500000 0.00
+ 0.169778980000 0.00
+ 0.169779000000 4.50
+ 0.171842980000 4.50
+ 0.171843000000 0.00
+ 0.186162480000 0.00
+ 0.186162500000 4.50
+ 0.188226980000 4.50
+ 0.188227000000 0.00
+ 0.202546980000 0.00
+ 0.202547000000 4.50
+ 0.204666980000 4.50
+ 0.204667000000 0.00
+ 0.218931480000 0.00
+ 0.218931500000 4.50
+ 0.220995980000 4.50
+ 0.220996000000 0.00
+ 0.235313980000 0.00
+ 0.235314000000 4.50
+ 0.237378480000 4.50
+ 0.237378500000 0.00
+ 0.251704980000 0.00
+ 0.251705000000 4.50
+ 0.253765480000 4.50
+ 0.253765500000 0.00
+ 0.268086980000 0.00
+ 0.268087000000 4.50
+ 0.270202480000 4.50
+ 0.270202500000 0.00
+ 0.284471980000 0.00
+ 0.284472000000 4.50
+ 0.286531480000 4.50
+ 0.286531500000 0.00
+ 0.300855480000 0.00
+ 0.300855500000 4.50
+ 0.302914480000 4.50
+ 0.302914500000 0.00
+ 0.317233980000 0.00
+ 0.317234000000 4.50
+ 0.319299480000 4.50
+ 0.319299500000 0.00
+ 0.333618480000 0.00
+ 0.333618500000 4.50
+ 0.335738480000 4.50
+ 0.335738500000 0.00
+ 0.350000000000 0.00
+ 0.350000020000 0.00
+ 0.370000000000 0.00
+ )
Vdrivecol7 col7cmd 0 PWL(
+ 0.000000000000 0.00
+ 0.008058480000 0.00
+ 0.008058500000 4.50
+ 0.010045480000 4.50
+ 0.010045500000 0.00
+ 0.024386980000 0.00
+ 0.024387000000 4.50
+ 0.026428980000 4.50
+ 0.026429000000 0.00
+ 0.040770480000 0.00
+ 0.040770500000 4.50
+ 0.042816480000 4.50
+ 0.042816500000 0.00
+ 0.057155480000 0.00
+ 0.057155500000 4.50
+ 0.059200480000 4.50
+ 0.059200500000 0.00
+ 0.073594480000 0.00
+ 0.073594500000 4.50
+ 0.075577480000 4.50
+ 0.075577500000 0.00
+ 0.089923480000 0.00
+ 0.089923500000 4.50
+ 0.091959980000 4.50
+ 0.091960000000 0.00
+ 0.106307980000 0.00
+ 0.106308000000 4.50
+ 0.108346980000 4.50
+ 0.108347000000 0.00
+ 0.122690480000 0.00
+ 0.122690500000 4.50
+ 0.124728480000 4.50
+ 0.124728500000 0.00
+ 0.139130480000 0.00
+ 0.139130500000 4.50
+ 0.141113480000 4.50
+ 0.141113500000 0.00
+ 0.155459480000 0.00
+ 0.155459500000 4.50
+ 0.157496480000 4.50
+ 0.157496500000 0.00
+ 0.171842980000 0.00
+ 0.171843000000 4.50
+ 0.173882480000 4.50
+ 0.173882500000 0.00
+ 0.188226980000 0.00
+ 0.188227000000 4.50
+ 0.190263980000 4.50
+ 0.190264000000 0.00
+ 0.204666980000 0.00
+ 0.204667000000 4.50
+ 0.206648480000 4.50
+ 0.206648500000 0.00
+ 0.220995980000 0.00
+ 0.220996000000 4.50
+ 0.223031980000 4.50
+ 0.223032000000 0.00
+ 0.237378480000 0.00
+ 0.237378500000 4.50
+ 0.239416980000 4.50
+ 0.239417000000 0.00
+ 0.253765480000 0.00
+ 0.253765500000 4.50
+ 0.255799980000 4.50
+ 0.255800000000 0.00
+ 0.270202480000 0.00
+ 0.270202500000 4.50
+ 0.272185480000 4.50
+ 0.272185500000 0.00
+ 0.286531480000 0.00
+ 0.286531500000 4.50
+ 0.288568480000 4.50
+ 0.288568500000 0.00
+ 0.302914480000 0.00
+ 0.302914500000 4.50
+ 0.304954980000 4.50
+ 0.304955000000 0.00
+ 0.319299480000 0.00
+ 0.319299500000 4.50
+ 0.321336980000 4.50
+ 0.321337000000 0.00
+ 0.335738480000 0.00
+ 0.335738500000 4.50
+ 0.337723980000 4.50
+ 0.337724000000 0.00
+ 0.350000000000 0.00
+ 0.350000020000 0.00
+ 0.370000000000 0.00
+ )
Routc0 col0cmd col0in 40
Xdriver0 col0in col0sink TBD62083CH
Rserc0 col0sink col0g 1k
Rgsc0 col0g rail 1.5k
Xcol0 col0drain col0g rail IRFR5305
Vcol0 col0drain col0 0
Routr0 row0cmd row0q 40
Rg0 row0q row0g 100
Rpd0 row0g 0 10k
Xrow0 row0 row0g row0s IRLR024N
Vrow0 row0s row0sh 0
Rsh0 row0sh 0 .22
Rsense0 row0s row0sense 1k
Csense0 row0sense 0 100n
Xcmp0 ref row0sense clr0 LM339
Rclr0 clr0 vcc 10k
Routc1 col1cmd col1in 40
Xdriver1 col1in col1sink TBD62083CH
Rserc1 col1sink col1g 1k
Rgsc1 col1g rail 1.5k
Xcol1 col1drain col1g rail IRFR5305
Vcol1 col1drain col1 0
Routr1 row1cmd row1q 40
Rg1 row1q row1g 100
Rpd1 row1g 0 10k
Xrow1 row1 row1g row1s IRLR024N
Vrow1 row1s row1sh 0
Rsh1 row1sh 0 .22
Rsense1 row1s row1sense 1k
Csense1 row1sense 0 100n
Xcmp1 ref row1sense clr1 LM339
Rclr1 clr1 vcc 10k
Routc2 col2cmd col2in 40
Xdriver2 col2in col2sink TBD62083CH
Rserc2 col2sink col2g 1k
Rgsc2 col2g rail 1.5k
Xcol2 col2drain col2g rail IRFR5305
Vcol2 col2drain col2 0
Routr2 row2cmd row2q 40
Rg2 row2q row2g 100
Rpd2 row2g 0 10k
Xrow2 row2 row2g row2s IRLR024N
Vrow2 row2s row2sh 0
Rsh2 row2sh 0 .22
Rsense2 row2s row2sense 1k
Csense2 row2sense 0 100n
Xcmp2 ref row2sense clr2 LM339
Rclr2 clr2 vcc 10k
Routc3 col3cmd col3in 40
Xdriver3 col3in col3sink TBD62083CH
Rserc3 col3sink col3g 1k
Rgsc3 col3g rail 1.5k
Xcol3 col3drain col3g rail IRFR5305
Vcol3 col3drain col3 0
Routr3 row3cmd row3q 40
Rg3 row3q row3g 100
Rpd3 row3g 0 10k
Xrow3 row3 row3g row3s IRLR024N
Vrow3 row3s row3sh 0
Rsh3 row3sh 0 .22
Rsense3 row3s row3sense 1k
Csense3 row3sense 0 100n
Xcmp3 ref row3sense clr3 LM339
Rclr3 clr3 vcc 10k
Routc4 col4cmd col4in 40
Xdriver4 col4in col4sink TBD62083CH
Rserc4 col4sink col4g 1k
Rgsc4 col4g rail 1.5k
Xcol4 col4drain col4g rail IRFR5305
Vcol4 col4drain col4 0
Routr4 row4cmd row4q 40
Rg4 row4q row4g 100
Rpd4 row4g 0 10k
Xrow4 row4 row4g row4s IRLR024N
Vrow4 row4s row4sh 0
Rsh4 row4sh 0 .22
Rsense4 row4s row4sense 1k
Csense4 row4sense 0 100n
Xcmp4 ref row4sense clr4 LM339
Rclr4 clr4 vcc 10k
Routc5 col5cmd col5in 40
Xdriver5 col5in col5sink TBD62083CH
Rserc5 col5sink col5g 1k
Rgsc5 col5g rail 1.5k
Xcol5 col5drain col5g rail IRFR5305
Vcol5 col5drain col5 0
Routr5 row5cmd row5q 40
Rg5 row5q row5g 100
Rpd5 row5g 0 10k
Xrow5 row5 row5g row5s IRLR024N
Vrow5 row5s row5sh 0
Rsh5 row5sh 0 .22
Rsense5 row5s row5sense 1k
Csense5 row5sense 0 100n
Xcmp5 ref row5sense clr5 LM339
Rclr5 clr5 vcc 10k
Routc6 col6cmd col6in 40
Xdriver6 col6in col6sink TBD62083CH
Rserc6 col6sink col6g 1k
Rgsc6 col6g rail 1.5k
Xcol6 col6drain col6g rail IRFR5305
Vcol6 col6drain col6 0
Routr6 row6cmd row6q 40
Rg6 row6q row6g 100
Rpd6 row6g 0 10k
Xrow6 row6 row6g row6s IRLR024N
Vrow6 row6s row6sh 0
Rsh6 row6sh 0 .22
Rsense6 row6s row6sense 1k
Csense6 row6sense 0 100n
Xcmp6 ref row6sense clr6 LM339
Rclr6 clr6 vcc 10k
Routc7 col7cmd col7in 40
Xdriver7 col7in col7sink TBD62083CH
Rserc7 col7sink col7g 1k
Rgsc7 col7g rail 1.5k
Xcol7 col7drain col7g rail IRFR5305
Vcol7 col7drain col7 0
Routr7 row7cmd row7q 40
Rg7 row7q row7g 100
Rpd7 row7g 0 10k
Xrow7 row7 row7g row7s IRLR024N
Vrow7 row7s row7sh 0
Rsh7 row7sh 0 .22
Rsense7 row7s row7sense 1k
Csense7 row7sense 0 100n
Xcmp7 ref row7sense clr7 LM339
Rclr7 clr7 vcc 10k
Blamp00 col0 a00 I=v(col0,a00)/(7+18*max(v(t00),0))
Dlamp00 a00 row0 D1N4004
Bheat00 0 t00 I=(v(col0,a00)^2/(7+18*max(v(t00),0)))/1.6
Cthermal00 t00 0 15m
Rthermal00 t00 0 1
Blamp01 col0 a01 I=v(col0,a01)/(7+18*max(v(t01),0))
Dlamp01 a01 row1 D1N4004
Bheat01 0 t01 I=(v(col0,a01)^2/(7+18*max(v(t01),0)))/1.6
Cthermal01 t01 0 15m
Rthermal01 t01 0 1
Blamp02 col0 a02 I=v(col0,a02)/(7+18*max(v(t02),0))
Dlamp02 a02 row2 D1N4004
Bheat02 0 t02 I=(v(col0,a02)^2/(7+18*max(v(t02),0)))/1.6
Cthermal02 t02 0 15m
Rthermal02 t02 0 1
Blamp03 col0 a03 I=v(col0,a03)/(7+18*max(v(t03),0))
Dlamp03 a03 row3 D1N4004
Bheat03 0 t03 I=(v(col0,a03)^2/(7+18*max(v(t03),0)))/1.6
Cthermal03 t03 0 15m
Rthermal03 t03 0 1
Blamp04 col0 a04 I=v(col0,a04)/(7+18*max(v(t04),0))
Dlamp04 a04 row4 D1N4004
Bheat04 0 t04 I=(v(col0,a04)^2/(7+18*max(v(t04),0)))/1.6
Cthermal04 t04 0 15m
Rthermal04 t04 0 1
Blamp05 col0 a05 I=v(col0,a05)/(7+18*max(v(t05),0))
Dlamp05 a05 row5 D1N4004
Bheat05 0 t05 I=(v(col0,a05)^2/(7+18*max(v(t05),0)))/1.6
Cthermal05 t05 0 15m
Rthermal05 t05 0 1
Blamp06 col0 a06 I=v(col0,a06)/(7+18*max(v(t06),0))
Dlamp06 a06 row6 D1N4004
Bheat06 0 t06 I=(v(col0,a06)^2/(7+18*max(v(t06),0)))/1.6
Cthermal06 t06 0 15m
Rthermal06 t06 0 1
Blamp07 col0 a07 I=v(col0,a07)/(7+18*max(v(t07),0))
Dlamp07 a07 row7 D1N4004
Bheat07 0 t07 I=(v(col0,a07)^2/(7+18*max(v(t07),0)))/1.6
Cthermal07 t07 0 15m
Rthermal07 t07 0 1
Blamp10 col1 a10 I=v(col1,a10)/(7+18*max(v(t10),0))
Dlamp10 a10 row0 D1N4004
Bheat10 0 t10 I=(v(col1,a10)^2/(7+18*max(v(t10),0)))/1.6
Cthermal10 t10 0 15m
Rthermal10 t10 0 1
Blamp11 col1 a11 I=v(col1,a11)/(7+18*max(v(t11),0))
Dlamp11 a11 row1 D1N4004
Bheat11 0 t11 I=(v(col1,a11)^2/(7+18*max(v(t11),0)))/1.6
Cthermal11 t11 0 15m
Rthermal11 t11 0 1
Blamp12 col1 a12 I=v(col1,a12)/(7+18*max(v(t12),0))
Dlamp12 a12 row2 D1N4004
Bheat12 0 t12 I=(v(col1,a12)^2/(7+18*max(v(t12),0)))/1.6
Cthermal12 t12 0 15m
Rthermal12 t12 0 1
Blamp13 col1 a13 I=v(col1,a13)/(7+18*max(v(t13),0))
Dlamp13 a13 row3 D1N4004
Bheat13 0 t13 I=(v(col1,a13)^2/(7+18*max(v(t13),0)))/1.6
Cthermal13 t13 0 15m
Rthermal13 t13 0 1
Blamp14 col1 a14 I=v(col1,a14)/(7+18*max(v(t14),0))
Dlamp14 a14 row4 D1N4004
Bheat14 0 t14 I=(v(col1,a14)^2/(7+18*max(v(t14),0)))/1.6
Cthermal14 t14 0 15m
Rthermal14 t14 0 1
Blamp15 col1 a15 I=v(col1,a15)/(7+18*max(v(t15),0))
Dlamp15 a15 row5 D1N4004
Bheat15 0 t15 I=(v(col1,a15)^2/(7+18*max(v(t15),0)))/1.6
Cthermal15 t15 0 15m
Rthermal15 t15 0 1
Blamp16 col1 a16 I=v(col1,a16)/(7+18*max(v(t16),0))
Dlamp16 a16 row6 D1N4004
Bheat16 0 t16 I=(v(col1,a16)^2/(7+18*max(v(t16),0)))/1.6
Cthermal16 t16 0 15m
Rthermal16 t16 0 1
Blamp17 col1 a17 I=v(col1,a17)/(7+18*max(v(t17),0))
Dlamp17 a17 row7 D1N4004
Bheat17 0 t17 I=(v(col1,a17)^2/(7+18*max(v(t17),0)))/1.6
Cthermal17 t17 0 15m
Rthermal17 t17 0 1
Blamp20 col2 a20 I=v(col2,a20)/(7+18*max(v(t20),0))
Dlamp20 a20 row0 D1N4004
Bheat20 0 t20 I=(v(col2,a20)^2/(7+18*max(v(t20),0)))/1.6
Cthermal20 t20 0 15m
Rthermal20 t20 0 1
Blamp21 col2 a21 I=v(col2,a21)/(7+18*max(v(t21),0))
Dlamp21 a21 row1 D1N4004
Bheat21 0 t21 I=(v(col2,a21)^2/(7+18*max(v(t21),0)))/1.6
Cthermal21 t21 0 15m
Rthermal21 t21 0 1
Blamp22 col2 a22 I=v(col2,a22)/(7+18*max(v(t22),0))
Dlamp22 a22 row2 D1N4004
Bheat22 0 t22 I=(v(col2,a22)^2/(7+18*max(v(t22),0)))/1.6
Cthermal22 t22 0 15m
Rthermal22 t22 0 1
Blamp23 col2 a23 I=v(col2,a23)/(7+18*max(v(t23),0))
Dlamp23 a23 row3 D1N4004
Bheat23 0 t23 I=(v(col2,a23)^2/(7+18*max(v(t23),0)))/1.6
Cthermal23 t23 0 15m
Rthermal23 t23 0 1
Blamp24 col2 a24 I=v(col2,a24)/(7+18*max(v(t24),0))
Dlamp24 a24 row4 D1N4004
Bheat24 0 t24 I=(v(col2,a24)^2/(7+18*max(v(t24),0)))/1.6
Cthermal24 t24 0 15m
Rthermal24 t24 0 1
Blamp25 col2 a25 I=v(col2,a25)/(7+18*max(v(t25),0))
Dlamp25 a25 row5 D1N4004
Bheat25 0 t25 I=(v(col2,a25)^2/(7+18*max(v(t25),0)))/1.6
Cthermal25 t25 0 15m
Rthermal25 t25 0 1
Blamp26 col2 a26 I=v(col2,a26)/(7+18*max(v(t26),0))
Dlamp26 a26 row6 D1N4004
Bheat26 0 t26 I=(v(col2,a26)^2/(7+18*max(v(t26),0)))/1.6
Cthermal26 t26 0 15m
Rthermal26 t26 0 1
Blamp27 col2 a27 I=v(col2,a27)/(7+18*max(v(t27),0))
Dlamp27 a27 row7 D1N4004
Bheat27 0 t27 I=(v(col2,a27)^2/(7+18*max(v(t27),0)))/1.6
Cthermal27 t27 0 15m
Rthermal27 t27 0 1
Blamp30 col3 a30 I=v(col3,a30)/(7+18*max(v(t30),0))
Dlamp30 a30 row0 D1N4004
Bheat30 0 t30 I=(v(col3,a30)^2/(7+18*max(v(t30),0)))/1.6
Cthermal30 t30 0 15m
Rthermal30 t30 0 1
Blamp31 col3 a31 I=v(col3,a31)/(7+18*max(v(t31),0))
Dlamp31 a31 row1 D1N4004
Bheat31 0 t31 I=(v(col3,a31)^2/(7+18*max(v(t31),0)))/1.6
Cthermal31 t31 0 15m
Rthermal31 t31 0 1
Blamp32 col3 a32 I=v(col3,a32)/(7+18*max(v(t32),0))
Dlamp32 a32 row2 D1N4004
Bheat32 0 t32 I=(v(col3,a32)^2/(7+18*max(v(t32),0)))/1.6
Cthermal32 t32 0 15m
Rthermal32 t32 0 1
Blamp33 col3 a33 I=v(col3,a33)/(7+18*max(v(t33),0))
Dlamp33 a33 row3 D1N4004
Bheat33 0 t33 I=(v(col3,a33)^2/(7+18*max(v(t33),0)))/1.6
Cthermal33 t33 0 15m
Rthermal33 t33 0 1
Blamp34 col3 a34 I=v(col3,a34)/(7+18*max(v(t34),0))
Dlamp34 a34 row4 D1N4004
Bheat34 0 t34 I=(v(col3,a34)^2/(7+18*max(v(t34),0)))/1.6
Cthermal34 t34 0 15m
Rthermal34 t34 0 1
Blamp35 col3 a35 I=v(col3,a35)/(7+18*max(v(t35),0))
Dlamp35 a35 row5 D1N4004
Bheat35 0 t35 I=(v(col3,a35)^2/(7+18*max(v(t35),0)))/1.6
Cthermal35 t35 0 15m
Rthermal35 t35 0 1
Blamp36 col3 a36 I=v(col3,a36)/(7+18*max(v(t36),0))
Dlamp36 a36 row6 D1N4004
Bheat36 0 t36 I=(v(col3,a36)^2/(7+18*max(v(t36),0)))/1.6
Cthermal36 t36 0 15m
Rthermal36 t36 0 1
Blamp37 col3 a37 I=v(col3,a37)/(7+18*max(v(t37),0))
Dlamp37 a37 row7 D1N4004
Bheat37 0 t37 I=(v(col3,a37)^2/(7+18*max(v(t37),0)))/1.6
Cthermal37 t37 0 15m
Rthermal37 t37 0 1
Blamp40 col4 a40 I=v(col4,a40)/(7+18*max(v(t40),0))
Dlamp40 a40 row0 D1N4004
Bheat40 0 t40 I=(v(col4,a40)^2/(7+18*max(v(t40),0)))/1.6
Cthermal40 t40 0 15m
Rthermal40 t40 0 1
Blamp41 col4 a41 I=v(col4,a41)/(7+18*max(v(t41),0))
Dlamp41 a41 row1 D1N4004
Bheat41 0 t41 I=(v(col4,a41)^2/(7+18*max(v(t41),0)))/1.6
Cthermal41 t41 0 15m
Rthermal41 t41 0 1
Blamp42 col4 a42 I=v(col4,a42)/(7+18*max(v(t42),0))
Dlamp42 a42 row2 D1N4004
Bheat42 0 t42 I=(v(col4,a42)^2/(7+18*max(v(t42),0)))/1.6
Cthermal42 t42 0 15m
Rthermal42 t42 0 1
Blamp43 col4 a43 I=v(col4,a43)/(7+18*max(v(t43),0))
Dlamp43 a43 row3 D1N4004
Bheat43 0 t43 I=(v(col4,a43)^2/(7+18*max(v(t43),0)))/1.6
Cthermal43 t43 0 15m
Rthermal43 t43 0 1
Blamp44 col4 a44 I=v(col4,a44)/(7+18*max(v(t44),0))
Dlamp44 a44 row4 D1N4004
Bheat44 0 t44 I=(v(col4,a44)^2/(7+18*max(v(t44),0)))/1.6
Cthermal44 t44 0 15m
Rthermal44 t44 0 1
Blamp45 col4 a45 I=v(col4,a45)/(7+18*max(v(t45),0))
Dlamp45 a45 row5 D1N4004
Bheat45 0 t45 I=(v(col4,a45)^2/(7+18*max(v(t45),0)))/1.6
Cthermal45 t45 0 15m
Rthermal45 t45 0 1
Blamp46 col4 a46 I=v(col4,a46)/(7+18*max(v(t46),0))
Dlamp46 a46 row6 D1N4004
Bheat46 0 t46 I=(v(col4,a46)^2/(7+18*max(v(t46),0)))/1.6
Cthermal46 t46 0 15m
Rthermal46 t46 0 1
Blamp47 col4 a47 I=v(col4,a47)/(7+18*max(v(t47),0))
Dlamp47 a47 row7 D1N4004
Bheat47 0 t47 I=(v(col4,a47)^2/(7+18*max(v(t47),0)))/1.6
Cthermal47 t47 0 15m
Rthermal47 t47 0 1
Blamp50 col5 a50 I=v(col5,a50)/(7+18*max(v(t50),0))
Dlamp50 a50 row0 D1N4004
Bheat50 0 t50 I=(v(col5,a50)^2/(7+18*max(v(t50),0)))/1.6
Cthermal50 t50 0 15m
Rthermal50 t50 0 1
Blamp51 col5 a51 I=v(col5,a51)/(7+18*max(v(t51),0))
Dlamp51 a51 row1 D1N4004
Bheat51 0 t51 I=(v(col5,a51)^2/(7+18*max(v(t51),0)))/1.6
Cthermal51 t51 0 15m
Rthermal51 t51 0 1
Blamp52 col5 a52 I=v(col5,a52)/(7+18*max(v(t52),0))
Dlamp52 a52 row2 D1N4004
Bheat52 0 t52 I=(v(col5,a52)^2/(7+18*max(v(t52),0)))/1.6
Cthermal52 t52 0 15m
Rthermal52 t52 0 1
Blamp53 col5 a53 I=v(col5,a53)/(7+18*max(v(t53),0))
Dlamp53 a53 row3 D1N4004
Bheat53 0 t53 I=(v(col5,a53)^2/(7+18*max(v(t53),0)))/1.6
Cthermal53 t53 0 15m
Rthermal53 t53 0 1
Blamp54 col5 a54 I=v(col5,a54)/(7+18*max(v(t54),0))
Dlamp54 a54 row4 D1N4004
Bheat54 0 t54 I=(v(col5,a54)^2/(7+18*max(v(t54),0)))/1.6
Cthermal54 t54 0 15m
Rthermal54 t54 0 1
Blamp55 col5 a55 I=v(col5,a55)/(7+18*max(v(t55),0))
Dlamp55 a55 row5 D1N4004
Bheat55 0 t55 I=(v(col5,a55)^2/(7+18*max(v(t55),0)))/1.6
Cthermal55 t55 0 15m
Rthermal55 t55 0 1
Blamp56 col5 a56 I=v(col5,a56)/(7+18*max(v(t56),0))
Dlamp56 a56 row6 D1N4004
Bheat56 0 t56 I=(v(col5,a56)^2/(7+18*max(v(t56),0)))/1.6
Cthermal56 t56 0 15m
Rthermal56 t56 0 1
Blamp57 col5 a57 I=v(col5,a57)/(7+18*max(v(t57),0))
Dlamp57 a57 row7 D1N4004
Bheat57 0 t57 I=(v(col5,a57)^2/(7+18*max(v(t57),0)))/1.6
Cthermal57 t57 0 15m
Rthermal57 t57 0 1
Blamp60 col6 a60 I=v(col6,a60)/(7+18*max(v(t60),0))
Dlamp60 a60 row0 D1N4004
Bheat60 0 t60 I=(v(col6,a60)^2/(7+18*max(v(t60),0)))/1.6
Cthermal60 t60 0 15m
Rthermal60 t60 0 1
Blamp61 col6 a61 I=v(col6,a61)/(7+18*max(v(t61),0))
Dlamp61 a61 row1 D1N4004
Bheat61 0 t61 I=(v(col6,a61)^2/(7+18*max(v(t61),0)))/1.6
Cthermal61 t61 0 15m
Rthermal61 t61 0 1
Blamp62 col6 a62 I=v(col6,a62)/(7+18*max(v(t62),0))
Dlamp62 a62 row2 D1N4004
Bheat62 0 t62 I=(v(col6,a62)^2/(7+18*max(v(t62),0)))/1.6
Cthermal62 t62 0 15m
Rthermal62 t62 0 1
Blamp63 col6 a63 I=v(col6,a63)/(7+18*max(v(t63),0))
Dlamp63 a63 row3 D1N4004
Bheat63 0 t63 I=(v(col6,a63)^2/(7+18*max(v(t63),0)))/1.6
Cthermal63 t63 0 15m
Rthermal63 t63 0 1
Blamp64 col6 a64 I=v(col6,a64)/(7+18*max(v(t64),0))
Dlamp64 a64 row4 D1N4004
Bheat64 0 t64 I=(v(col6,a64)^2/(7+18*max(v(t64),0)))/1.6
Cthermal64 t64 0 15m
Rthermal64 t64 0 1
Blamp65 col6 a65 I=v(col6,a65)/(7+18*max(v(t65),0))
Dlamp65 a65 row5 D1N4004
Bheat65 0 t65 I=(v(col6,a65)^2/(7+18*max(v(t65),0)))/1.6
Cthermal65 t65 0 15m
Rthermal65 t65 0 1
Blamp66 col6 a66 I=v(col6,a66)/(7+18*max(v(t66),0))
Dlamp66 a66 row6 D1N4004
Bheat66 0 t66 I=(v(col6,a66)^2/(7+18*max(v(t66),0)))/1.6
Cthermal66 t66 0 15m
Rthermal66 t66 0 1
Blamp67 col6 a67 I=v(col6,a67)/(7+18*max(v(t67),0))
Dlamp67 a67 row7 D1N4004
Bheat67 0 t67 I=(v(col6,a67)^2/(7+18*max(v(t67),0)))/1.6
Cthermal67 t67 0 15m
Rthermal67 t67 0 1
Blamp70 col7 a70 I=v(col7,a70)/(7+18*max(v(t70),0))
Dlamp70 a70 row0 D1N4004
Bheat70 0 t70 I=(v(col7,a70)^2/(7+18*max(v(t70),0)))/1.6
Cthermal70 t70 0 15m
Rthermal70 t70 0 1
Blamp71 col7 a71 I=v(col7,a71)/(7+18*max(v(t71),0))
Dlamp71 a71 row1 D1N4004
Bheat71 0 t71 I=(v(col7,a71)^2/(7+18*max(v(t71),0)))/1.6
Cthermal71 t71 0 15m
Rthermal71 t71 0 1
Blamp72 col7 a72 I=v(col7,a72)/(7+18*max(v(t72),0))
Dlamp72 a72 row2 D1N4004
Bheat72 0 t72 I=(v(col7,a72)^2/(7+18*max(v(t72),0)))/1.6
Cthermal72 t72 0 15m
Rthermal72 t72 0 1
Blamp73 col7 a73 I=v(col7,a73)/(7+18*max(v(t73),0))
Dlamp73 a73 row3 D1N4004
Bheat73 0 t73 I=(v(col7,a73)^2/(7+18*max(v(t73),0)))/1.6
Cthermal73 t73 0 15m
Rthermal73 t73 0 1
Blamp74 col7 a74 I=v(col7,a74)/(7+18*max(v(t74),0))
Dlamp74 a74 row4 D1N4004
Bheat74 0 t74 I=(v(col7,a74)^2/(7+18*max(v(t74),0)))/1.6
Cthermal74 t74 0 15m
Rthermal74 t74 0 1
Blamp75 col7 a75 I=v(col7,a75)/(7+18*max(v(t75),0))
Dlamp75 a75 row5 D1N4004
Bheat75 0 t75 I=(v(col7,a75)^2/(7+18*max(v(t75),0)))/1.6
Cthermal75 t75 0 15m
Rthermal75 t75 0 1
Blamp76 col7 a76 I=v(col7,a76)/(7+18*max(v(t76),0))
Dlamp76 a76 row6 D1N4004
Bheat76 0 t76 I=(v(col7,a76)^2/(7+18*max(v(t76),0)))/1.6
Cthermal76 t76 0 15m
Rthermal76 t76 0 1
Blamp77 col7 a77 I=v(col7,a77)/(7+18*max(v(t77),0))
Dlamp77 a77 row7 D1N4004
Bheat77 0 t77 I=(v(col7,a77)^2/(7+18*max(v(t77),0)))/1.6
Cthermal77 t77 0 15m
Rthermal77 t77 0 1
.save v(clr0) v(row0) v(row0s) v(col0drain) i(Vrow0) i(Vcol0) v(clr1) v(row1) v(row1s) v(col1drain) i(Vrow1) i(Vcol1) v(clr2) v(row2) v(row2s) v(col2drain) i(Vrow2) i(Vcol2) v(clr3) v(row3) v(row3s) v(col3drain) i(Vrow3) i(Vcol3) v(clr4) v(row4) v(row4s) v(col4drain) i(Vrow4) i(Vcol4) v(clr5) v(row5) v(row5s) v(col5drain) i(Vrow5) i(Vcol5) v(clr6) v(row6) v(row6s) v(col6drain) i(Vrow6) i(Vcol6) v(clr7) v(row7) v(row7s) v(col7drain) i(Vrow7) i(Vcol7)
.options method=trap klu reltol=.001 itl4=500
.tran 5u 0.370000000 0 1u
.control
run
let sim_end=time[length(time)-1]
print sim_end
let pc0=(20.69-v(col0drain))*i(Vcol0)
let pr0=(v(row0)-v(row0s))*i(Vrow0)
let ir0=abs(i(Vrow0))
let ic0=abs(i(Vcol0))
meas tran col0_peak MAX ic0
meas tran row0_peak MAX ir0
meas tran row0_clear MIN v(clr0)
meas tran col0_power AVG pc0 from=0.100000000 to=0.350000000
meas tran row0_power AVG pr0 from=0.100000000 to=0.350000000
let col0_tj=50+col0_power*110
let row0_tj=50+row0_power*110
print col0_tj
print row0_tj
let pc1=(20.69-v(col1drain))*i(Vcol1)
let pr1=(v(row1)-v(row1s))*i(Vrow1)
let ir1=abs(i(Vrow1))
let ic1=abs(i(Vcol1))
meas tran col1_peak MAX ic1
meas tran row1_peak MAX ir1
meas tran row1_clear MIN v(clr1)
meas tran col1_power AVG pc1 from=0.100000000 to=0.350000000
meas tran row1_power AVG pr1 from=0.100000000 to=0.350000000
let col1_tj=50+col1_power*110
let row1_tj=50+row1_power*110
print col1_tj
print row1_tj
let pc2=(20.69-v(col2drain))*i(Vcol2)
let pr2=(v(row2)-v(row2s))*i(Vrow2)
let ir2=abs(i(Vrow2))
let ic2=abs(i(Vcol2))
meas tran col2_peak MAX ic2
meas tran row2_peak MAX ir2
meas tran row2_clear MIN v(clr2)
meas tran col2_power AVG pc2 from=0.100000000 to=0.350000000
meas tran row2_power AVG pr2 from=0.100000000 to=0.350000000
let col2_tj=50+col2_power*110
let row2_tj=50+row2_power*110
print col2_tj
print row2_tj
let pc3=(20.69-v(col3drain))*i(Vcol3)
let pr3=(v(row3)-v(row3s))*i(Vrow3)
let ir3=abs(i(Vrow3))
let ic3=abs(i(Vcol3))
meas tran col3_peak MAX ic3
meas tran row3_peak MAX ir3
meas tran row3_clear MIN v(clr3)
meas tran col3_power AVG pc3 from=0.100000000 to=0.350000000
meas tran row3_power AVG pr3 from=0.100000000 to=0.350000000
let col3_tj=50+col3_power*110
let row3_tj=50+row3_power*110
print col3_tj
print row3_tj
let pc4=(20.69-v(col4drain))*i(Vcol4)
let pr4=(v(row4)-v(row4s))*i(Vrow4)
let ir4=abs(i(Vrow4))
let ic4=abs(i(Vcol4))
meas tran col4_peak MAX ic4
meas tran row4_peak MAX ir4
meas tran row4_clear MIN v(clr4)
meas tran col4_power AVG pc4 from=0.100000000 to=0.350000000
meas tran row4_power AVG pr4 from=0.100000000 to=0.350000000
let col4_tj=50+col4_power*110
let row4_tj=50+row4_power*110
print col4_tj
print row4_tj
let pc5=(20.69-v(col5drain))*i(Vcol5)
let pr5=(v(row5)-v(row5s))*i(Vrow5)
let ir5=abs(i(Vrow5))
let ic5=abs(i(Vcol5))
meas tran col5_peak MAX ic5
meas tran row5_peak MAX ir5
meas tran row5_clear MIN v(clr5)
meas tran col5_power AVG pc5 from=0.100000000 to=0.350000000
meas tran row5_power AVG pr5 from=0.100000000 to=0.350000000
let col5_tj=50+col5_power*110
let row5_tj=50+row5_power*110
print col5_tj
print row5_tj
let pc6=(20.69-v(col6drain))*i(Vcol6)
let pr6=(v(row6)-v(row6s))*i(Vrow6)
let ir6=abs(i(Vrow6))
let ic6=abs(i(Vcol6))
meas tran col6_peak MAX ic6
meas tran row6_peak MAX ir6
meas tran row6_clear MIN v(clr6)
meas tran col6_power AVG pc6 from=0.100000000 to=0.350000000
meas tran row6_power AVG pr6 from=0.100000000 to=0.350000000
let col6_tj=50+col6_power*110
let row6_tj=50+row6_power*110
print col6_tj
print row6_tj
let pc7=(20.69-v(col7drain))*i(Vcol7)
let pr7=(v(row7)-v(row7s))*i(Vrow7)
let ir7=abs(i(Vrow7))
let ic7=abs(i(Vcol7))
meas tran col7_peak MAX ic7
meas tran row7_peak MAX ir7
meas tran row7_clear MIN v(clr7)
meas tran col7_power AVG pc7 from=0.100000000 to=0.350000000
meas tran row7_power AVG pr7 from=0.100000000 to=0.350000000
let col7_tj=50+col7_power*110
let row7_tj=50+row7_power*110
print col7_tj
print row7_tj
.endc
.end
