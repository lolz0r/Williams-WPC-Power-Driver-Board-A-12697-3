Actual coil-1 ROM pulses with only settled OFF time compressed; coil1_vendor_strict_klu_0.125us
.include /home/lolz0r/repros/wpc_power_driver_cost/variants/jlcpcb/tools/spice/models.lib
.include /home/lolz0r/repros/wpc_power_driver_cost/variants/jlcpcb/.scratch/vendor-models/S3M.spice.txt
Vcmd cmd 0 PWL(
+ 0.000000000000 0
+ 0.049999980000 0
+ 0.050000000000 4.5
+ 0.052064480000 4.5
+ 0.052064500000 0
+ 0.058192480000 0
+ 0.058192500000 4.5
+ 0.060254980000 4.5
+ 0.060255000000 0
+ 0.066384480000 0
+ 0.066384500000 4.5
+ 0.069311480000 4.5
+ 0.069311500000 0
+ 0.075439980000 0
+ 0.075440000000 4.5
+ 0.077502980000 4.5
+ 0.077503000000 0
+ 0.083631980000 0
+ 0.083632000000 4.5
+ 0.085694980000 4.5
+ 0.085695000000 0
+ 0.091823480000 0
+ 0.091823500000 4.5
+ 0.093886480000 4.5
+ 0.093886500000 0
+ 0.100014480000 0
+ 0.100014500000 4.5
+ 0.102078480000 4.5
+ 0.102078500000 0
+ 0.107357480000 0
+ 0.107357500000 4.5
+ 0.110269980000 4.5
+ 0.110270000000 0
+ 0.115535980000 0
+ 0.115536000000 4.5
+ 0.118462980000 4.5
+ 0.118463000000 0
+ 0.123728980000 0
+ 0.123729000000 4.5
+ 0.127839980000 4.5
+ 0.127840000000 0
+ 0.132783980000 0
+ 0.132784000000 4.5
+ 0.136030980000 4.5
+ 0.136031000000 0
+ 0.140974980000 0
+ 0.140975000000 4.5
+ 0.144223480000 4.5
+ 0.144223500000 0
+ 0.149167480000 0
+ 0.149167500000 4.5
+ 0.152416480000 4.5
+ 0.152416500000 0
+ 0.157358480000 0
+ 0.157358500000 4.5
+ 0.160607480000 4.5
+ 0.160607500000 0
+ 0.165550980000 0
+ 0.165551000000 4.5
+ 0.168812980000 4.5
+ 0.168813000000 0
+ 0.172879480000 0
+ 0.172879500000 4.5
+ 0.176990980000 4.5
+ 0.176991000000 0
+ 0.181072480000 0
+ 0.181072500000 4.5
+ 0.186173980000 4.5
+ 0.186174000000 0
+ 0.190126480000 0
+ 0.190126500000 4.5
+ 0.194239480000 4.5
+ 0.194239500000 0
+ 0.198318980000 0
+ 0.198319000000 4.5
+ 0.202501480000 4.5
+ 0.202501500000 0
+ 0.206510980000 0
+ 0.206511000000 4.5
+ 0.210622480000 4.5
+ 0.210622500000 0
+ 0.214702980000 0
+ 0.214703000000 4.5
+ 0.218884980000 4.5
+ 0.218885000000 0
+ 0.222894980000 0
+ 0.222895000000 4.5
+ 0.227007480000 4.5
+ 0.227007500000 0
+ 0.237238980000 0
+ 0.237239000000 4.5
+ 0.243389980000 4.5
+ 0.243390000000 0
+ 0.245422480000 0
+ 0.245422500000 4.5
+ 0.251709980000 4.5
+ 0.251710000000 0
+ 0.253620980000 0
+ 0.253621000000 4.5
+ 0.260958980000 4.5
+ 0.260959000000 0
+ 0.262991480000 0
+ 0.262991500000 4.5
+ 0.269150980000 4.5
+ 0.269151000000 0
+ 0.271184980000 0
+ 0.271185000000 4.5
+ 0.277344480000 4.5
+ 0.277344500000 0
+ 0.279376980000 0
+ 0.279377000000 4.5
+ 0.285535480000 4.5
+ 0.285535500000 0
+ 0.287567980000 0
+ 0.287568000000 4.5
+ 0.353114480000 4.5
+ 0.353114500000 0
+ 0.453114480000 0
+ 0.453114500000 4.5
+ 0.456362980000 4.5
+ 0.456363000000 0
+ 0.462490480000 0
+ 0.462490500000 4.5
+ 0.464553980000 4.5
+ 0.464554000000 0
+ 0.470682480000 0
+ 0.470682500000 4.5
+ 0.472748980000 4.5
+ 0.472749000000 0
+ 0.478874980000 0
+ 0.478875000000 4.5
+ 0.480937980000 4.5
+ 0.480938000000 0
+ 0.487066980000 0
+ 0.487067000000 4.5
+ 0.489131480000 4.5
+ 0.489131500000 0
+ 0.495259480000 0
+ 0.495259500000 4.5
+ 0.497321980000 4.5
+ 0.497322000000 0
+ 0.503452980000 0
+ 0.503453000000 4.5
+ 0.505514980000 4.5
+ 0.505515000000 0
+ 0.510470480000 0
+ 0.510470500000 4.5
+ 0.514575480000 4.5
+ 0.514575500000 0
+ 0.519835980000 0
+ 0.519836000000 4.5
+ 0.522761980000 4.5
+ 0.522762000000 0
+ 0.528033480000 0
+ 0.528033500000 4.5
+ 0.530959980000 4.5
+ 0.530960000000 0
+ 0.536218480000 0
+ 0.536218500000 4.5
+ 0.539148980000 4.5
+ 0.539149000000 0
+ 0.544413480000 0
+ 0.544413500000 4.5
+ 0.547346480000 4.5
+ 0.547346500000 0
+ 0.552603980000 0
+ 0.552604000000 4.5
+ 0.555530980000 4.5
+ 0.555531000000 0
+ 0.560794980000 0
+ 0.560795000000 4.5
+ 0.563727980000 4.5
+ 0.563728000000 0
+ 0.568987480000 0
+ 0.568987500000 4.5
+ 0.573098480000 4.5
+ 0.573098500000 0
+ 0.577179980000 0
+ 0.577180000000 4.5
+ 0.581291480000 4.5
+ 0.581291500000 0
+ 0.585370480000 0
+ 0.585370500000 4.5
+ 0.589482480000 4.5
+ 0.589482500000 0
+ 0.593563480000 0
+ 0.593563500000 4.5
+ 0.597674480000 4.5
+ 0.597674500000 0
+ 0.601754980000 0
+ 0.601755000000 4.5
+ 0.605865980000 4.5
+ 0.605866000000 0
+ 0.609948980000 0
+ 0.609949000000 4.5
+ 0.614058480000 4.5
+ 0.614058500000 0
+ 0.618140480000 0
+ 0.618140500000 4.5
+ 0.622249980000 4.5
+ 0.622250000000 0
+ 0.626331480000 0
+ 0.626331500000 4.5
+ 0.631304980000 4.5
+ 0.631305000000 0
+ 0.633350480000 0
+ 0.633350500000 4.5
+ 0.639496980000 4.5
+ 0.639497000000 0
+ 0.641530980000 0
+ 0.641531000000 4.5
+ 0.647690480000 4.5
+ 0.647690500000 0
+ 0.649721480000 0
+ 0.649721500000 4.5
+ 0.655881980000 4.5
+ 0.655882000000 0
+ 0.657913480000 0
+ 0.657913500000 4.5
+ 0.664073980000 4.5
+ 0.664074000000 0
+ 0.666108980000 0
+ 0.666109000000 4.5
+ 0.672265480000 4.5
+ 0.672265500000 0
+ 0.674297980000 0
+ 0.674298000000 4.5
+ 0.680458480000 4.5
+ 0.680458500000 0
+ 0.682490980000 0
+ 0.682491000000 4.5
+ 0.689834980000 4.5
+ 0.689835000000 0
+ 0.691867480000 0
+ 0.691867500000 4.5
+ 0.756233480000 4.5
+ 0.756233500000 0
+ 0.806233500000 0
+ )
Vrail rail 0 86
Ro cmd a 40
Rg a gate 100
Rpd gate 0 10k
Vsense drain dq 0
XQ dq gate 0 IPD90N10S4L06
Lcoil drain cl 12m
Rcoil cl rail 3.78
Dfly drain rail DI_S3M
.save v(dq) v(gate) i(Vsense) i(Lcoil) @m.xq.m1[id] @d.xq.db[id] @d.xq.db[capcur]
.options method=trap klu reltol=.0001 trtol=1 chgtol=1e-16 itl4=500
.tran 1u 0.806233500000 0 0.125u
.control
run
let loss_channel=v(dq)*@m.xq.m1[id]
let loss_body=-v(dq)*(@d.xq.db[id]-@d.xq.db[capcur])
let loss_total=loss_channel+loss_body
let terminal_power=v(dq)*i(Vsense)
let icoil=abs(i(Lcoil))
let sim_end=time[length(time)-1]
print sim_end
meas tran e_dissipation INTEG loss_total
meas tran e_terminal INTEG terminal_power
meas tran vds_peak MAX v(dq)
meas tran coil_peak MAX icoil
meas tran fet_terminal_peak MAX i(Vsense)
let dissipation_W=e_dissipation/10
let terminal_W=e_terminal/10
let tj_dissipation=50+dissipation_W*62
let tj_terminal=50+terminal_W*62
print dissipation_W
print terminal_W
print tj_dissipation
print tj_terminal
.endc
.end
