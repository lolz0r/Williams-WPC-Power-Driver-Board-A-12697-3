G.I. string cold start through F106 and the triac: 18 x #44 lamps (6.3 V / 0.25 A: 2.5 R cold -> 25 R hot, thermal tau ~60 ms) on the 6.8 VAC winding at the STTNG-measured 7.87 VAC unloaded (11.1 V peak, 0.05 R per leg), F106 = Littelfuse 239 5 A S.B. 5x20 mm (nominal melting I2t 302.8 A2s), BTA16-600C (Vt0 0.85 V / Rd 25 mOhm, ITSM 160 A, I2t 128 A2s) in the return leg (MT1 to GND_REF), gate held from the voltage peak at 4.17 ms (worst-case first firing, level 0 = full on). Measures the inrush peak, the I2t through fuse and triac, the steady rms string current against the 5 A fuse and the triac dissipation.
.include ../models.lib
VCC vcc 0 5
* 18 #44 lamps in parallel, one thermal state (identical lamps): I = 18 x v / (2.5 (1 + 9 th)), heating per lamp
.subckt LAMP18 a b
Blamp a b I = 18 * v(a,b) / (2.5 * (1 + 9 * max(v(th), 0)))
Bheat 0 th I = v(a,b) * v(a,b) / (2.5 * (1 + 9 * max(v(th), 0)))
Cth th 0 0.095
Rth th 0 0.63
.ends
Vac ac0 0 SIN(0 11.1 60)
Rw ac0 ac 0.1
Vf106 ac acf 0
XS acf mt2 LAMP18
Vmt mt2 mt2i 0
Btri mt2i 0 I = ( max((abs(i(Vg)) > 0.05), (v(on) > 0.5)) > 0.5 ) ? ( (v(mt2i) > 0) ? max(v(mt2i) - 0.85, 0) / 0.025 : min(v(mt2i) + 0.85, 0) / 0.025 ) : v(mt2i) * 1e-6
Bon onr 0 V = (abs(i(Vmt)) > 0.05) ? 1 : 0
Ron onr on 1
Con on 0 0.5u
* gate drive: latch bit held from 4.17 ms (74HCT574 Q 4.6 V / 40 R -> 470 R -> MMBT4401 -> 27 R)
VL latch 0 PULSE(0 4.6 4.17m 20n 20n 1 2)
RL latch a 40
Rb a b 470
Rpd b 0 10k
Q1 vcc b e QMMBT4401
Vg e eg 0
R27 eg g 27
Dg g 0 DGATE
Rgk g 0 200
.model DGATE D(Is=1e-9 n=2 Rs=5)
.options reltol=0.005 method=gear
.tran 20u 400m
.control
run
let istr = i(Vf106)
let iabs = abs(istr)
let isq = istr * istr
let ptri = v(mt2i) * i(Vmt)
meas tran ipk MAX iabs from=0 to=30m
meas tran i2t_f106 INTEG isq from=0 to=300m
meas tran i2t_30ms INTEG isq from=0 to=30m
meas tran irms_ss RMS istr from=300m to=400m
meas tran p_triac AVG ptri from=300m to=400m
meas tran istr_pre MAX iabs from=0 to=4m
* junction rise with the Boyd 7020BG heatsink: Rth(j-a) = 2.5 + 0.5 + 8.7 x 1.25 = 13.875 C/W (see gi_gate); limit 75 C (Tj 125 C at 50 C ambient)
let tj_rise_sink = p_triac * 13.875
print tj_rise_sink
wrdata /home/lolz0r/tng/wpc_power_driver_cost/output/spice/gi_string.csv v(ac) istr ptri
.endc
.end
