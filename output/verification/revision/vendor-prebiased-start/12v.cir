TI TPS54360 transient model, 12v actual compensation, Vin=20.69
.include /Users/mc/Williams-WPC-Power-Driver-Board-A-12697-3-/.scratch/vendor-models/SLVMCT7/TPS54360_PSPICE_TRANS/TPS54360_TRANS.LIB
.include /Users/mc/Williams-WPC-Power-Driver-Board-A-12697-3-/tools/spice/models.lib
Vin vin 0 20.69
Rin vin vinf .02
Venctl enctl 0 PWL(0 1 200u 1 201u 0)
Sen en 0 enctl 0 PRE
Cin vinf 0 20u
XU boot comp en 0 sw rt vinf fb 0 TPS54360_TRANS
Ren1 vinf en 130k
Ren2 en 0 20k
Rrt rt 0 240k
Cboot boot sw 100n
Rfb1 vout fb 28k
Rfb2 fb 0 2k
Rc comp cc 42.2k
Cc cc 0 100n
Cp comp 0 390p
Dcatch 0 sw DB560C
L1 sw linductor 10u
Rdcr linductor vout .025
Cout1 vout c1 330u
Resr1 c1 0 .045
Cout2 vout c2 330u
Resr2 c2 0 .045
Cc3 vout 0 10u
Vpre pre 0 6.0
Vprectl prectl 0 PWL(0 1 200u 1 201u 0)
Spre pre vout prectl 0 PRE
.model PRE SW(Ron=.02 Roff=1e12 Vt=.5 Vh=.1)
Rload vout 0 16.0
Istep vout 0 0
.save v(vout) v(sw) v(comp) i(L1)
.options reltol=.005 abstol=1u vntol=1m method=gear
.tran 100n 8m
.control
run
meas tran output_peak MAX v(vout)
meas tran output_min MIN v(vout) from=20u to=8m
meas tran recovery AVG v(vout) from=7.5m to=8m
meas tran inductor_peak MAX i(L1)
meas tran inductor_min MIN i(L1)
.endc
.end
