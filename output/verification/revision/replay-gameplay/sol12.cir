ROM raw-write replay channel 12; bus.csv
.include /Users/mc/Williams-WPC-Power-Driver-Board-A-12697-3-/tools/spice/models.lib
Vrail rail 0 86
Vcmd cmd 0 PWL(
+ 0.000000000000 0.00
+ 0.199999980000 0.00
+ 0.200000000000 4.50
+ 0.264672480000 4.50
+ 0.264672500000 0.00
+ 7.542070980000 0.00
+ 7.542071000000 4.50
+ 7.606752480000 4.50
+ 7.606752500000 0.00
+ 8.883511480000 0.00
+ 8.883511500000 4.50
+ 8.948192980000 4.50
+ 8.948193000000 0.00
+ 10.200000000000 0.00
+ 10.200000020000 0.00
+ 10.230000000000 0.00
+ )
Rout cmd gateinput 40
Rg gateinput gate 100
Rpd gate 0 10k
Vsense drain drainq 0
XQ drainq gate 0 IPD90N10S4L06
Lcoil drain coil 0.025
Rcoil coil rail 9.72
Vdiode drain diode 0
Dfly diode rail DS3M
.save v(drainq) v(gate) i(Vsense) i(Vdiode) i(Lcoil)
.options reltol=0.002 method=trap maxord=2
.tran 100u 10.230000000 0 5u
.control
set numdgt=12
run
let pfet=v(drainq)*i(Vsense)
* Average forward current; exclude physical reverse leakage from the forward rating.
let id=(abs(i(Vdiode))+i(Vdiode))/2
let icoil=abs(i(Lcoil))
let sim_end=time[length(time)-1]
print sim_end
meas tran vds_peak MAX v(drainq)
meas tran vgs_peak MAX v(gate)
meas tran p_avg AVG pfet from=0.200000000 to=10.200000000
meas tran id_avg AVG id from=0.200000000 to=10.200000000
meas tran i_peak MAX i(Vsense)
meas tran coil_peak MAX icoil
let tj_repeating=50+p_avg*62
print tj_repeating
.endc
.end
