Modern G.I. gate drive and triac dissipation: 74HCT574 -> 470R -> MMBT4401 emitter follower (10k pull-down) -> 27R -> BTA16-600C gate (macro fires at 50 mA = worst-case Q IV Igt, holds while |I| > 50 mA); on-state modelled with the BTA16 datasheet Vt0 = 0.85 V / Rd = 25 mOhm so that the conduction loss is real; 18 x #44 string (1.4 R hot) on 6.3 VAC (8.9 V peak)
.include ../models.lib
VCC vcc 0 5
VL latch 0 PULSE(0 4.6 2m 20n 20n 60m 100m)
RL latch a 40
Rb a b 470
Rpd b 0 10k
Q1 vcc b e QMMBT4401
Vg e eg 0
R27 eg g 27
Dg g 0 DGATE
Rgk g 0 200
.model DGATE D(Is=1e-9 n=2 Rs=5)
Vmt mt2 mt2i 0
Btri mt2i 0 I = ( max((abs(i(Vg)) > 0.05), (v(on) > 0.5)) > 0.5 ) ? ( (v(mt2i) > 0) ? max(v(mt2i) - 0.85, 0) / 0.025 : min(v(mt2i) + 0.85, 0) / 0.025 ) : v(mt2i) * 1e-6
Bon onr 0 V = (abs(i(Vmt)) > 0.05) ? 1 : 0
Ron onr on 1
Con on 0 0.5u
Vac ac 0 SIN(0 8.9 60)
Vstr ac acs 0
Rstr acs mt2 1.4
.tran 20u 80m
.control
run
let ig = i(Vg)
let istr = i(Vstr)
let istr_abs = abs(istr)
let pnpn = (v(vcc)-v(e))*ig
let ptri = v(mt2i)*i(Vmt)
meas tran ig_peak MAX ig from=2m to=60m
meas tran istr_off MAX istr_abs from=0 to=2m
meas tran istr_on MAX istr_abs from=20m to=60m
meas tran istr_rms RMS istr from=20m to=53.33m
meas tran istr_after MAX istr_abs from=70m to=80m
meas tran p_npn AVG pnpn from=20m to=60m
meas tran p_triac AVG ptri from=20m to=53.33m
meas tran i_latch MIN i(VL) from=2m to=60m
* junction rise with the Boyd 7019BG bolt-on channel heatsink (11.0 C/W natural convection at a 75 C rise, x1.15 for the ~50 C rise here = 12.65 C/W) + Rth(j-c) 2.5 (BTA insulated TO-220, ST) + interface 0.5 C/W
* = 15.65 C/W junction-to-ambient; requirement Tj <= 125 C at 50 C cabinet ambient -> rise <= 75 C.  (The previously specified 577002B00000G clip is 32 C/W per the Boyd catalogue, not 25: rise would be 115 C.)
let tj_rise_sink = p_triac * 15.65
let tj_rise_clip = p_triac * 35
let rth_sa_needed = 75 / p_triac - 3
print tj_rise_sink
print tj_rise_clip
print rth_sa_needed
wrdata /home/lolz0r/tng/wpc_power_driver_cost/output/spice/gi_gate.csv v(ac) v(mt2) istr ig ptri
.endc
.end
