Power-up / blanking sequence in the machine: the ~70 V, +18V and 6.8VAC rails are up from t=0, +5V comes up through the TPS54360B soft-start (2 ms ramp) at t=30 ms; BLANKING is an open-collector line from the CPU (2N3904, off during reset) pulled up by SR1 (4.7k) - it follows +5V up and stays HIGH until the CPU releases it at t=200 ms. Every latch is a 74HCT574 that powers up with a random content (worst case: all 1) and is tri-stated while /OE (= BLANKING) is above VCC/2; below VCC = 2 V an HCT output cannot drive. Paths: solenoid (IRLR3110Z + AE-23-800 on 70 V), G.I. (MMBT4401 + BTA16 macro + 6.8VAC string), lamp column (TBD62083A with its internal pull-down, IRFR5305 on +18V) with a row MOSFET that happens to be ON (74HCT74 random state). At t=200 ms the CPU pulls BLANKING low with the latches still holding 1 -> the outputs must then turn on (the path works); at 240 ms the CPU writes 0.
.include ../models.lib
V50 v50 0 70
V18 v18 0 18
Vac ac 0 SIN(0 9.6 60)
* +5V rail: 0 until 30 ms, then a 2 ms soft-start ramp to 5 V
Bvcc vcc 0 V = (time < 30m) ? 0 : min(5, (time - 30m) / 2m * 5)
* BLANKING: SR1 4.7k to VCC, CPU open collector (2N3904) closes at 200 ms
Rsr1 vcc blank 4.7k
Scpu blank 0 cpu 0 SWL
Vcpu cpu 0 PULSE(0 5 200m 1u 1u 1 2)
* latch data (what the latch holds): 1 until 240 ms, then 0
Bdat dat 0 V = (time < 240m) ? 1 : 0
* 74HCT574 behavioural output: driven to dat*VCC through 40 R only when VCC > 2 V and /OE < VCC/2, otherwise high impedance
Ben en 0 V = ((v(vcc) > 2.0) && (v(blank) < 0.5*v(vcc))) ? 1 : 0
Bq q 0 V = v(dat) * v(vcc)
Sq q lq en 0 SWL
Rq lq latch 40
.model SWL SW(Ron=0.01 Roff=1e9 Vt=0.5 Vh=0.1)
* ---- solenoid path
Rg latch g 100
Rpd g 0 10k
XQ out g 0 IRLR3110Z
Vcoil v50 v50c 0
Lc out cl 12m
Rc cl v50c 4.2
Dfb out v50 DS3M
* ---- G.I. path (latch shared)
Rb latch b 470
Rpdb b 0 10k
Q1 vcc b e QMMBT4401
Vg e eg 0
R27 eg gt 27
Dg gt 0 DGATE
Rgk gt 0 200
.model DGATE D(Is=1e-9 n=2 Rs=5)
Vmt mt2 mt2i 0
Btri mt2i 0 I = v(mt2i) * ( max((abs(i(Vg)) > 0.05), (v(on) > 0.5)) > 0.5 ? 20 : 1e-6 )
Bon onr 0 V = (abs(i(Vmt)) > 0.05) ? 1 : 0
Ron onr on 1
Con on 0 0.5u
Vstr ac acs 0
Rstr acs mt2 1.4
* ---- lamp column path: latch (tri-stated) -> TBD62083A input (internal pull-down, modelled 100k) -> IRFR5305 column; row MOSFET forced ON (random 74HCT74 state); 8 hot lamps = 3 ohm
Rtbd latch tin 0
Rtbdpd tin 0 100k
XU19 tin ulnout TBD62083CH
Rser ulnout cg 1k
Rgs cg v18 1.5k
XQC col cg v18 IRFR5305
Vcol col colx 0
Rlamps colx rowd 3
Vrowg rg 0 4.6
Rrg rg rgate 100
XQR rowd rgate re IRLR024N
Rsense re 0 0.22
.tran 20u 300m
.control
run
let icoil = i(Vcoil)
let istr = abs(i(Vstr))
let icol = i(Vcol)
meas tran icoil_blank MAX icoil from=0 to=199m
meas tran istr_blank MAX istr from=0 to=199m
meas tran icol_blank MAX icol from=0 to=199m
meas tran vgate_blank MAX v(g) from=0 to=199m
meas tran blank_min MIN v(blank) from=33m to=199m
meas tran icoil_on MAX icoil from=200m to=240m
meas tran istr_on MAX istr from=200m to=240m
meas tran icol_on MAX icol from=200m to=240m
meas tran icoil_after MAX icoil from=260m to=300m
meas tran icol_after MAX icol from=260m to=300m
wrdata /home/lolz0r/tng/wpc_power_driver_cost/output/spice/powerup.csv v(vcc) v(blank) v(g) icoil istr icol
.endc
.end
