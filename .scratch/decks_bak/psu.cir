Cost-board power supplies: +18V = 13VAC / GBJ1510 / 2 x 10000uF at 2.8 A (5 ohm), +5V = 9VAC / GBU8J / 10000uF -> TPS54360B buck (averaged: eta 0.88, Dmax 0.97) at 3 A, +12V = +20V rail (GBJ1510 / 10000uF) -> buck at 2 A while a 4 A flasher pulse loads +20V, +50V = GBPC3510 / 2 x 2200uF with a 12 A coil pulse
.include ../models.lib
* ---- +18V lamp supply (13VAC, GBJ1510, 2 x 10000uF, 5 ohm = 2.8 A average lamp-matrix load)
V13 l1 l2 SIN(0 18.4 60)
Rl1 l1 la 0.05
Rl2 l2 lb 0.05
DL1 la v18 DGBJ15
DL2 lb v18 DGBJ15
DL3 0 la DGBJ15
DL4 0 lb DGBJ15
C6 v18 0 10000u
C7 v18 0 10000u
Rl18 v18 0 5
* ---- +5V: 9VAC -> BR2 (GBU8J) -> C5 10000uF -> buck U20 (3 A load = 1.667 ohm)
V9 s1 s2 SIN(0 12.7 60)
Rs1 s1 sa 0.05
Rs2 s2 sb 0.05
DS1 sa vraw DGBU8
DS2 sb vraw DGBU8
DS3 0 sa DGBU8
DS4 0 sb DGBU8
C5 vraw 0 10000u
Bv5 v5 0 V = min(5.0, max(0.97*v(vraw) - 0.5, 0))
R5 v5 0 1.667
Bin5 vraw 0 I = (v(v5)*v(v5)/1.667) / (0.88*max(v(vraw),1))
* ---- +20V flasher supply (16VAC, GBJ1510, 10000uF) feeding the +12V buck U21 (2 A load) ; 4 A flasher burst 40..140 ms
V16 f1 f2 SIN(0 22.6 60)
Rf1 f1 fa 0.05
Rf2 f2 fb 0.05
DF1 fa v20 DGBJ15
DF2 fb v20 DGBJ15
DF3 0 fa DGBJ15
DF4 0 fb DGBJ15
C11 v20 0 10000u
Sfl v20 fln ctl2 0 SWS
Rflash fln 0 5
Vctl2 ctl2 0 PULSE(0 5 40m 1u 1u 100m 300m)
Bv12 v12 0 V = min(12.0, max(0.97*v(v20) - 0.5, 0))
R12 v12 0 6
Bin12 v20 0 I = (v(v12)*v(v12)/6) / (0.88*max(v(v20),1))
* ---- +50V solenoid supply, 36VAC, GBPC3510, 2 x 2200uF/100V, bleeder ; 4 ohm coil pulsed 40 ms at t=60 ms
V36 h1 h2 SIN(0 51 60)
Rh1 h1 ha 0.1
Rh2 h2 hb 0.1
DH1 ha v50 DGBPC35
DH2 hb v50 DGBPC35
DH3 0 ha DGBPC35
DH4 0 hb DGBPC35
C8 v50 0 2200u
C32 v50 0 2200u
R260 v50 0 10k
Ssol v50 coil ctl 0 SWS
Vctl ctl 0 PULSE(0 5 60m 1u 1u 40m 200m)
.model SWS SW(Ron=0.05 Roff=1e9 Vt=2.5 Vh=0.1)
Lcoil coil cn 12m
Rcoil cn 0 4
Dfb 0 coil D1N4004
Dfb2 coil v50 D1N4004
.tran 20u 150m uic
.control
run
meas tran v18_avg AVG v(v18) from=80m to=120m
meas tran v18_ripple PP v(v18) from=80m to=120m
meas tran vin5_min MIN v(vraw) from=80m to=120m
meas tran v5_min MIN v(v5) from=80m to=120m
meas tran v5_max MAX v(v5) from=80m to=120m
meas tran v50_idle AVG v(v50) from=40m to=60m
meas tran v50_avg_pulse AVG v(v50) from=70m to=99m
meas tran v50_min_pulse MIN v(v50) from=70m to=99m
let icoil = i(Lcoil)
meas tran icoil_max MAX icoil from=60m to=100m
meas tran v20_min MIN v(v20) from=80m to=140m
meas tran v12_min MIN v(v12) from=80m to=140m
meas tran v12_max MAX v(v12) from=80m to=140m
meas tran vin5_ripple PP v(vraw) from=80m to=120m
meas tran v20_ripple PP v(v20) from=80m to=120m
wrdata /home/lolz0r/tng/wpc_power_driver_cost/output/spice/psu.csv v(v18) v(vraw) v(v5) v(v50) icoil v(v20) v(v12)
.endc
.end
