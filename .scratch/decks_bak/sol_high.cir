Cost-board high-power solenoid driver (sol 1-8): 74HCT574 -> 100R -> IRLR3110Z DPAK (10k pull-down) -> 4 ohm coil on +50V, S3M tie-back
.include ../models.lib
V50 v50 0 50
VL latch 0 PULSE(0 4.6 1m 20n 20n 40m 100m)
RL latch a 40
Rg a g 100
Rpd g 0 10k
XQ out g 0 IRLR3110Z
Vcoil v50 v50c 0
Lc out cl 12m
Rc cl v50c 4
Dfb out v50 DS3M
.tran 5u 60m
.control
run
let icoil = i(Vcoil)
let pfet = v(out)*icoil
meas tran icoil_max MAX icoil from=1m to=41m
meas tran vout_on AVG v(out) from=30m to=40m
meas tran vout_peak MAX v(out) from=41m to=60m
meas tran p_fet AVG pfet from=30m to=40m
meas tran icoil_off MAX icoil from=56m to=60m
wrdata /home/lolz0r/tng/wpc_power_driver_cost/output/spice/sol_high.csv v(out) icoil v(g)
.endc
.end
